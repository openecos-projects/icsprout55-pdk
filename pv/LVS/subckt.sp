* SPICE NETLIST
***************************************

.SUBCKT var1p2_npd_nw_lp POS NEG
.ENDS
***************************************
.SUBCKT var2p5_npd_nw_lp POS NEG
.ENDS
***************************************
.SUBCKT var3p3_npd_nw_lp POS NEG
.ENDS
***************************************
.SUBCKT re_ndif_2t POS NEG
.ENDS
***************************************
.SUBCKT re_pdif_2t POS NEG
.ENDS
***************************************
.SUBCKT re_ndif_3t POS NEG SUB
.ENDS
***************************************
.SUBCKT re_pdif_3t POS NEG SUB
.ENDS
***************************************
.SUBCKT re_ndif_sab_2t POS NEG
.ENDS
***************************************
.SUBCKT re_pdif_sab_2t POS NEG
.ENDS
***************************************
.SUBCKT re_ndif_sab_3t POS NEG SUB
.ENDS
***************************************
.SUBCKT re_pdif_sab_3t POS NEG SUB
.ENDS
***************************************
.SUBCKT re_nwaa_2t POS NEG
.ENDS
***************************************
.SUBCKT re_nwsti_2t POS NEG
.ENDS
***************************************
.SUBCKT re_nwaa_3t POS NEG SUB
.ENDS
***************************************
.SUBCKT re_nwsti_3t POS NEG SUB
.ENDS
***************************************
.SUBCKT re_npo_2t POS NEG
.ENDS
***************************************
.SUBCKT re_ppo_2t POS NEG
.ENDS
***************************************
.SUBCKT re_npo_sab_2t POS NEG
.ENDS
***************************************
.SUBCKT re_ppo_sab_2t POS NEG
.ENDS
***************************************
.SUBCKT re_hrpo_2t POS NEG
.ENDS
***************************************
.SUBCKT re_npo_3t POS NEG SUB
.ENDS
***************************************
.SUBCKT re_ppo_3t POS NEG SUB
.ENDS
***************************************
.SUBCKT re_npo_sab_3t POS NEG SUB
.ENDS
***************************************
.SUBCKT re_ppo_sab_3t POS NEG SUB
.ENDS
***************************************
.SUBCKT re_hrpo_3t POS NEG SUB
.ENDS
***************************************
.SUBCKT re_m1_2t POS NEG
.ENDS
***************************************
.SUBCKT re_m2_2t POS NEG
.ENDS
***************************************
.SUBCKT re_m1_3t POS NEG SUB
.ENDS
***************************************
.SUBCKT re_m2_3t POS NEG SUB
.ENDS
***************************************
.SUBCKT re_m3_2t POS NEG
.ENDS
***************************************
.SUBCKT re_m4_2t POS NEG
.ENDS
***************************************
.SUBCKT re_m5_2t POS NEG
.ENDS
***************************************
.SUBCKT re_m6_2t POS NEG
.ENDS
***************************************
.SUBCKT re_m7_2t POS NEG
.ENDS
***************************************
.SUBCKT re_m8_2t POS NEG
.ENDS
***************************************
.SUBCKT re_m3_3t POS NEG SUB
.ENDS
***************************************
.SUBCKT re_m4_3t POS NEG SUB
.ENDS
***************************************
.SUBCKT re_m5_3t POS NEG SUB
.ENDS
***************************************
.SUBCKT re_m6_3t POS NEG SUB
.ENDS
***************************************
.SUBCKT re_m7_3t POS NEG SUB
.ENDS
***************************************
.SUBCKT re_m8_3t POS NEG SUB
.ENDS
***************************************
.SUBCKT re_tm1_2t POS NEG
.ENDS
***************************************
.SUBCKT re_tm1_3t POS NEG SUB
.ENDS
***************************************
.SUBCKT re_tm2_2t POS NEG
.ENDS
***************************************
.SUBCKT re_tm2_3t POS NEG SUB
.ENDS
***************************************
.SUBCKT re_alpa_2t POS NEG
.ENDS
***************************************
.SUBCKT re_alpa_3t POS NEG SUB
.ENDS
***************************************
.SUBCKT mom_2t PLUS MINUS
.ENDS
***************************************
.SUBCKT mom_3t PLUS MINUS B
.ENDS
***************************************
