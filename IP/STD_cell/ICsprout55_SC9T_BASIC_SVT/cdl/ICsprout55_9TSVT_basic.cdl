.SUBCKT ADDFCINX0P5_9TSVT A B CIN CO S VDD VSS VNW VPW
MNM15 CO net50 VSS VPW nm1p2_svt_lp W=230e-9 L=60e-9 MR=1
MNM14 net50 out CC VPW nm1p2_svt_lp W=230e-9 L=60e-9 MR=1
MNM13 net50 outn BN VPW nm1p2_svt_lp W=230e-9 L=60e-9 MR=1
MNM11 S net35 VSS VPW nm1p2_svt_lp W=230e-9 L=60e-9 MR=1
MNM10 net35 out CN VPW nm1p2_svt_lp W=230e-9 L=60e-9 MR=1
MNM9 net35 outn CC VPW nm1p2_svt_lp W=230e-9 L=60e-9 MR=1
MNM8 CC CN VSS VPW nm1p2_svt_lp W=230e-9 L=60e-9 MR=1
MNM7 CN CIN VSS VPW nm1p2_svt_lp W=230e-9 L=60e-9 MR=1
MNM5 outn out VSS VPW nm1p2_svt_lp W=230e-9 L=60e-9 MR=1
MNM4 out BN AA VPW nm1p2_svt_lp W=230e-9 L=60e-9 MR=1
MNM3 out B AN VPW nm1p2_svt_lp W=230e-9 L=60e-9 MR=1
MNM2 AA AN VSS VPW nm1p2_svt_lp W=230e-9 L=60e-9 MR=1
MNM1 AN A VSS VPW nm1p2_svt_lp W=230e-9 L=60e-9 MR=1
MNM0 BN B VSS VPW nm1p2_svt_lp W=230e-9 L=60e-9 MR=1
MPM15 CO net50 VDD VNW pm1p2_svt_lp W=300e-9 L=60e-9 MR=1
MPM14 net50 outn CC VNW pm1p2_svt_lp W=300e-9 L=60e-9 MR=1
MPM13 net50 out BN VNW pm1p2_svt_lp W=300e-9 L=60e-9 MR=1
MPM11 S net35 VDD VNW pm1p2_svt_lp W=300e-9 L=60e-9 MR=1
MPM10 net35 outn CN VNW pm1p2_svt_lp W=300e-9 L=60e-9 MR=1
MPM9 net35 out CC VNW pm1p2_svt_lp W=300e-9 L=60e-9 MR=1
MPM8 CC CN VDD VNW pm1p2_svt_lp W=300e-9 L=60e-9 MR=1
MPM7 CN CIN VDD VNW pm1p2_svt_lp W=300e-9 L=60e-9 MR=1
MPM5 outn out VDD VNW pm1p2_svt_lp W=300e-9 L=60e-9 MR=1
MPM4 out B AA VNW pm1p2_svt_lp W=300e-9 L=60e-9 MR=1
MPM3 out BN AN VNW pm1p2_svt_lp W=300e-9 L=60e-9 MR=1
MPM2 AA AN VDD VNW pm1p2_svt_lp W=300e-9 L=60e-9 MR=1
MPM1 AN A VDD VNW pm1p2_svt_lp W=300e-9 L=60e-9 MR=1
MPM0 BN B VDD VNW pm1p2_svt_lp W=300e-9 L=60e-9 MR=1
.ENDS
.SUBCKT ADDFCINX1_9TSVT A B CIN CO S VDD VSS VNW VPW
MNM15 CO net50 VSS VPW nm1p2_svt_lp W=470e-9 L=60e-9 MR=1
MNM14 net50 out CC VPW nm1p2_svt_lp W=230n L=60n MR=1
MNM13 net50 outn BN VPW nm1p2_svt_lp W=230n L=60n MR=1
MNM11 S net35 VSS VPW nm1p2_svt_lp W=470e-9 L=60e-9 MR=1
MNM10 net35 out CN VPW nm1p2_svt_lp W=230n L=60n MR=1
MNM9 net35 outn CC VPW nm1p2_svt_lp W=230n L=60n MR=1
MNM8 CC CN VSS VPW nm1p2_svt_lp W=230n L=60n MR=1
MNM7 CN CIN VSS VPW nm1p2_svt_lp W=230n L=60n MR=1
MNM5 outn out VSS VPW nm1p2_svt_lp W=230n L=60n MR=1
MNM4 out BN AA VPW nm1p2_svt_lp W=230n L=60n MR=1
MNM3 out B AN VPW nm1p2_svt_lp W=230n L=60n MR=1
MNM2 AA AN VSS VPW nm1p2_svt_lp W=230n L=60n MR=1
MNM1 AN A VSS VPW nm1p2_svt_lp W=230n L=60n MR=1
MNM0 BN B VSS VPW nm1p2_svt_lp W=230n L=60n MR=1
MPM15 CO net50 VDD VNW pm1p2_svt_lp W=590e-9 L=60e-9 MR=1
MPM14 net50 outn CC VNW pm1p2_svt_lp W=300n L=60n MR=1
MPM13 net50 out BN VNW pm1p2_svt_lp W=300n L=60n MR=1
MPM11 S net35 VDD VNW pm1p2_svt_lp W=590e-9 L=60e-9 MR=1
MPM10 net35 outn CN VNW pm1p2_svt_lp W=300n L=60n MR=1
MPM9 net35 out CC VNW pm1p2_svt_lp W=300n L=60n MR=1
MPM8 CC CN VDD VNW pm1p2_svt_lp W=300n L=60n MR=1
MPM7 CN CIN VDD VNW pm1p2_svt_lp W=300n L=60n MR=1
MPM5 outn out VDD VNW pm1p2_svt_lp W=300n L=60n MR=1
MPM4 out B AA VNW pm1p2_svt_lp W=300n L=60n MR=1
MPM3 out BN AN VNW pm1p2_svt_lp W=300n L=60n MR=1
MPM2 AA AN VDD VNW pm1p2_svt_lp W=300n L=60n MR=1
MPM1 AN A VDD VNW pm1p2_svt_lp W=300n L=60n MR=1
MPM0 BN B VDD VNW pm1p2_svt_lp W=300n L=60n MR=1
.ENDS
.SUBCKT ADDFCINX2_9TSVT A B CIN CO S VDD VSS VNW VPW
MNM15 CO net50 VSS VPW nm1p2_svt_lp W=940e-9 L=60e-9 MR=1
MNM14 net50 out CC VPW nm1p2_svt_lp W=230n L=60n MR=1
MNM13 net50 outn BN VPW nm1p2_svt_lp W=230n L=60n MR=1
MNM11 S net35 VSS VPW nm1p2_svt_lp W=940e-9 L=60e-9 MR=1
MNM10 net35 out CN VPW nm1p2_svt_lp W=230n L=60n MR=1
MNM9 net35 outn CC VPW nm1p2_svt_lp W=230n L=60n MR=1
MNM8 CC CN VSS VPW nm1p2_svt_lp W=470e-9 L=60e-9 MR=1
MNM7 CN CIN VSS VPW nm1p2_svt_lp W=470e-9 L=60e-9 MR=1
MNM5 outn out VSS VPW nm1p2_svt_lp W=470e-9 L=60e-9 MR=1
MNM4 out BN AA VPW nm1p2_svt_lp W=230n L=60n MR=1
MNM3 out B AN VPW nm1p2_svt_lp W=230n L=60n MR=1
MNM2 AA AN VSS VPW nm1p2_svt_lp W=230n L=60n MR=1
MNM1 AN A VSS VPW nm1p2_svt_lp W=230n L=60n MR=1
MNM0 BN B VSS VPW nm1p2_svt_lp W=470e-9 L=60e-9 MR=1
MPM15 CO net50 VDD VNW pm1p2_svt_lp W=1.18e-6 L=60e-9 MR=1
MPM14 net50 outn CC VNW pm1p2_svt_lp W=300n L=60n MR=1
MPM13 net50 out BN VNW pm1p2_svt_lp W=300n L=60n MR=1
MPM11 S net35 VDD VNW pm1p2_svt_lp W=1.18e-6 L=60e-9 MR=1
MPM10 net35 outn CN VNW pm1p2_svt_lp W=300n L=60n MR=1
MPM9 net35 out CC VNW pm1p2_svt_lp W=300n L=60n MR=1
MPM8 CC CN VDD VNW pm1p2_svt_lp W=590e-9 L=60e-9 MR=1
MPM7 CN CIN VDD VNW pm1p2_svt_lp W=590e-9 L=60e-9 MR=1
MPM5 outn out VDD VNW pm1p2_svt_lp W=590e-9 L=60e-9 MR=1
MPM4 out B AA VNW pm1p2_svt_lp W=300n L=60n MR=1
MPM3 out BN AN VNW pm1p2_svt_lp W=300n L=60n MR=1
MPM2 AA AN VDD VNW pm1p2_svt_lp W=300n L=60n MR=1
MPM1 AN A VDD VNW pm1p2_svt_lp W=300n L=60n MR=1
MPM0 BN B VDD VNW pm1p2_svt_lp W=590e-9 L=60e-9 MR=1
.ENDS
.SUBCKT ADDFCINX4_9TSVT A B CIN CO S VDD VSS VNW VPW
MNM15 CO net50 VSS VPW nm1p2_svt_lp W=1.88e-6 L=60e-9 MR=1
MNM14 net50 out CC VPW nm1p2_svt_lp W=470e-9 L=60e-9 MR=1
MNM13 net50 outn BN VPW nm1p2_svt_lp W=470e-9 L=60e-9 MR=1
MNM11 S net35 VSS VPW nm1p2_svt_lp W=1.88e-6 L=60e-9 MR=1
MNM10 net35 out CN VPW nm1p2_svt_lp W=470e-9 L=60e-9 MR=1
MNM9 net35 outn CC VPW nm1p2_svt_lp W=470e-9 L=60e-9 MR=1
MNM8 CC CN VSS VPW nm1p2_svt_lp W=940e-9 L=60e-9 MR=1
MNM7 CN CIN VSS VPW nm1p2_svt_lp W=940e-9 L=60e-9 MR=1
MNM5 outn out VSS VPW nm1p2_svt_lp W=470e-9 L=60e-9 MR=1
MNM4 out BN AA VPW nm1p2_svt_lp W=470e-9 L=60e-9 MR=1
MNM3 out B AN VPW nm1p2_svt_lp W=470e-9 L=60e-9 MR=1
MNM2 AA AN VSS VPW nm1p2_svt_lp W=470n L=60n MR=1
MNM1 AN A VSS VPW nm1p2_svt_lp W=470n L=60n MR=1
MNM0 BN B VSS VPW nm1p2_svt_lp W=940e-9 L=60e-9 MR=1
MPM15 CO net50 VDD VNW pm1p2_svt_lp W=2.36e-6 L=60e-9 MR=1
MPM14 net50 outn CC VNW pm1p2_svt_lp W=590e-9 L=60e-9 MR=1
MPM13 net50 out BN VNW pm1p2_svt_lp W=590e-9 L=60e-9 MR=1
MPM11 S net35 VDD VNW pm1p2_svt_lp W=2.36e-6 L=60e-9 MR=1
MPM10 net35 outn CN VNW pm1p2_svt_lp W=590e-9 L=60e-9 MR=1
MPM9 net35 out CC VNW pm1p2_svt_lp W=590e-9 L=60e-9 MR=1
MPM8 CC CN VDD VNW pm1p2_svt_lp W=1.18e-6 L=60e-9 MR=1
MPM7 CN CIN VDD VNW pm1p2_svt_lp W=1.18e-6 L=60e-9 MR=1
MPM5 outn out VDD VNW pm1p2_svt_lp W=590e-9 L=60e-9 MR=1
MPM4 out B AA VNW pm1p2_svt_lp W=590e-9 L=60e-9 MR=1
MPM3 out BN AN VNW pm1p2_svt_lp W=590e-9 L=60e-9 MR=1
MPM2 AA AN VDD VNW pm1p2_svt_lp W=590n L=60n MR=1
MPM1 AN A VDD VNW pm1p2_svt_lp W=590n L=60n MR=1
MPM0 BN B VDD VNW pm1p2_svt_lp W=1.18e-6 L=60e-9 MR=1
.ENDS
.SUBCKT ADDFX0P5_9TSVT A B CI CO S VDD VSS VNW VPW
MNM15 CO net50 VSS VPW nm1p2_svt_lp W=230e-9 L=60e-9 MR=1
MNM14 net50 outn CN VPW nm1p2_svt_lp W=230e-9 L=60e-9 MR=1
MNM13 net50 out BN VPW nm1p2_svt_lp W=230e-9 L=60e-9 MR=1
MNM11 S net35 VSS VPW nm1p2_svt_lp W=230e-9 L=60e-9 MR=1
MNM10 net35 out CN VPW nm1p2_svt_lp W=230e-9 L=60e-9 MR=1
MNM9 net35 outn CC VPW nm1p2_svt_lp W=230e-9 L=60e-9 MR=1
MNM8 CC CN VSS VPW nm1p2_svt_lp W=230e-9 L=60e-9 MR=1
MNM7 CN CI VSS VPW nm1p2_svt_lp W=230e-9 L=60e-9 MR=1
MNM5 outn out VSS VPW nm1p2_svt_lp W=230e-9 L=60e-9 MR=1
MNM4 out BN AN VPW nm1p2_svt_lp W=230e-9 L=60e-9 MR=1
MNM3 out B AA VPW nm1p2_svt_lp W=230e-9 L=60e-9 MR=1
MNM2 AA AN VSS VPW nm1p2_svt_lp W=230e-9 L=60e-9 MR=1
MNM1 AN A VSS VPW nm1p2_svt_lp W=230e-9 L=60e-9 MR=1
MNM0 BN B VSS VPW nm1p2_svt_lp W=230e-9 L=60e-9 MR=1
MPM15 CO net50 VDD VNW pm1p2_svt_lp W=300e-9 L=60e-9 MR=1
MPM14 net50 out CN VNW pm1p2_svt_lp W=300e-9 L=60e-9 MR=1
MPM13 net50 outn BN VNW pm1p2_svt_lp W=300e-9 L=60e-9 MR=1
MPM11 S net35 VDD VNW pm1p2_svt_lp W=300e-9 L=60e-9 MR=1
MPM10 net35 outn CN VNW pm1p2_svt_lp W=300e-9 L=60e-9 MR=1
MPM9 net35 out CC VNW pm1p2_svt_lp W=300e-9 L=60e-9 MR=1
MPM8 CC CN VDD VNW pm1p2_svt_lp W=300e-9 L=60e-9 MR=1
MPM7 CN CI VDD VNW pm1p2_svt_lp W=300e-9 L=60e-9 MR=1
MPM5 outn out VDD VNW pm1p2_svt_lp W=300e-9 L=60e-9 MR=1
MPM4 out B AN VNW pm1p2_svt_lp W=300e-9 L=60e-9 MR=1
MPM3 out BN AA VNW pm1p2_svt_lp W=300e-9 L=60e-9 MR=1
MPM2 AA AN VDD VNW pm1p2_svt_lp W=300e-9 L=60e-9 MR=1
MPM1 AN A VDD VNW pm1p2_svt_lp W=300e-9 L=60e-9 MR=1
MPM0 BN B VDD VNW pm1p2_svt_lp W=300e-9 L=60e-9 MR=1
.ENDS
.SUBCKT ADDFX1_9TSVT A B CI CO S VDD VSS VNW VPW
MNM15 CO net50 VSS VPW nm1p2_svt_lp W=470e-9 L=60e-9 MR=1
MNM14 net50 outn CN VPW nm1p2_svt_lp W=230n L=60n MR=1
MNM13 net50 out BN VPW nm1p2_svt_lp W=230n L=60n MR=1
MNM11 S net35 VSS VPW nm1p2_svt_lp W=470e-9 L=60e-9 MR=1
MNM10 net35 out CN VPW nm1p2_svt_lp W=230n L=60n MR=1
MNM9 net35 outn CC VPW nm1p2_svt_lp W=230n L=60n MR=1
MNM8 CC CN VSS VPW nm1p2_svt_lp W=230n L=60n MR=1
MNM7 CN CI VSS VPW nm1p2_svt_lp W=230n L=60n MR=1
MNM5 outn out VSS VPW nm1p2_svt_lp W=230n L=60n MR=1
MNM4 out BN AN VPW nm1p2_svt_lp W=230n L=60n MR=1
MNM3 out B AA VPW nm1p2_svt_lp W=230n L=60n MR=1
MNM2 AA AN VSS VPW nm1p2_svt_lp W=230n L=60n MR=1
MNM1 AN A VSS VPW nm1p2_svt_lp W=230n L=60n MR=1
MNM0 BN B VSS VPW nm1p2_svt_lp W=230n L=60n MR=1
MPM15 CO net50 VDD VNW pm1p2_svt_lp W=590e-9 L=60e-9 MR=1
MPM14 net50 out CN VNW pm1p2_svt_lp W=300n L=60n MR=1
MPM13 net50 outn BN VNW pm1p2_svt_lp W=300n L=60n MR=1
MPM11 S net35 VDD VNW pm1p2_svt_lp W=590e-9 L=60e-9 MR=1
MPM10 net35 outn CN VNW pm1p2_svt_lp W=300n L=60n MR=1
MPM9 net35 out CC VNW pm1p2_svt_lp W=300n L=60n MR=1
MPM8 CC CN VDD VNW pm1p2_svt_lp W=300n L=60n MR=1
MPM7 CN CI VDD VNW pm1p2_svt_lp W=300n L=60n MR=1
MPM5 outn out VDD VNW pm1p2_svt_lp W=300n L=60n MR=1
MPM4 out B AN VNW pm1p2_svt_lp W=300n L=60n MR=1
MPM3 out BN AA VNW pm1p2_svt_lp W=300n L=60n MR=1
MPM2 AA AN VDD VNW pm1p2_svt_lp W=300n L=60n MR=1
MPM1 AN A VDD VNW pm1p2_svt_lp W=300n L=60n MR=1
MPM0 BN B VDD VNW pm1p2_svt_lp W=300n L=60n MR=1
.ENDS
.SUBCKT ADDFX2_9TSVT A B CI CO S VDD VSS VNW VPW
MNM15 CO net50 VSS VPW nm1p2_svt_lp W=940e-9 L=60e-9 MR=1
MNM14 net50 outn CN VPW nm1p2_svt_lp W=230n L=60n MR=1
MNM13 net50 out BN VPW nm1p2_svt_lp W=230n L=60n MR=1
MNM11 S net35 VSS VPW nm1p2_svt_lp W=940e-9 L=60e-9 MR=1
MNM10 net35 out CN VPW nm1p2_svt_lp W=230n L=60n MR=1
MNM9 net35 outn CC VPW nm1p2_svt_lp W=230n L=60n MR=1
MNM8 CC CN VSS VPW nm1p2_svt_lp W=470e-9 L=60e-9 MR=1
MNM7 CN CI VSS VPW nm1p2_svt_lp W=470e-9 L=60e-9 MR=1
MNM5 outn out VSS VPW nm1p2_svt_lp W=470e-9 L=60e-9 MR=1
MNM4 out BN AN VPW nm1p2_svt_lp W=230n L=60n MR=1
MNM3 out B AA VPW nm1p2_svt_lp W=230n L=60n MR=1
MNM2 AA AN VSS VPW nm1p2_svt_lp W=230n L=60n MR=1
MNM1 AN A VSS VPW nm1p2_svt_lp W=230n L=60n MR=1
MNM0 BN B VSS VPW nm1p2_svt_lp W=470e-9 L=60e-9 MR=1
MPM15 CO net50 VDD VNW pm1p2_svt_lp W=1.18e-6 L=60e-9 MR=1
MPM14 net50 out CN VNW pm1p2_svt_lp W=300n L=60n MR=1
MPM13 net50 outn BN VNW pm1p2_svt_lp W=300n L=60n MR=1
MPM11 S net35 VDD VNW pm1p2_svt_lp W=1.18e-6 L=60e-9 MR=1
MPM10 net35 outn CN VNW pm1p2_svt_lp W=300n L=60n MR=1
MPM9 net35 out CC VNW pm1p2_svt_lp W=300n L=60n MR=1
MPM8 CC CN VDD VNW pm1p2_svt_lp W=590e-9 L=60e-9 MR=1
MPM7 CN CI VDD VNW pm1p2_svt_lp W=590e-9 L=60e-9 MR=1
MPM5 outn out VDD VNW pm1p2_svt_lp W=590e-9 L=60e-9 MR=1
MPM4 out B AN VNW pm1p2_svt_lp W=300n L=60n MR=1
MPM3 out BN AA VNW pm1p2_svt_lp W=300n L=60n MR=1
MPM2 AA AN VDD VNW pm1p2_svt_lp W=300n L=60n MR=1
MPM1 AN A VDD VNW pm1p2_svt_lp W=300n L=60n MR=1
MPM0 BN B VDD VNW pm1p2_svt_lp W=590e-9 L=60e-9 MR=1
.ENDS
.SUBCKT ADDFX4_9TSVT A B CI CO S VDD VSS VNW VPW
MNM15 CO net50 VSS VPW nm1p2_svt_lp W=1.88e-6 L=60e-9 MR=1
MNM14 net50 outn CN VPW nm1p2_svt_lp W=470e-9 L=60e-9 MR=1
MNM13 net50 out BN VPW nm1p2_svt_lp W=470e-9 L=60e-9 MR=1
MNM11 S net35 VSS VPW nm1p2_svt_lp W=1.88e-6 L=60e-9 MR=1
MNM10 net35 out CN VPW nm1p2_svt_lp W=470e-9 L=60e-9 MR=1
MNM9 net35 outn CC VPW nm1p2_svt_lp W=470e-9 L=60e-9 MR=1
MNM8 CC CN VSS VPW nm1p2_svt_lp W=940e-9 L=60e-9 MR=1
MNM7 CN CI VSS VPW nm1p2_svt_lp W=940e-9 L=60e-9 MR=1
MNM5 outn out VSS VPW nm1p2_svt_lp W=470e-9 L=60e-9 MR=1
MNM4 out BN AN VPW nm1p2_svt_lp W=470e-9 L=60e-9 MR=1
MNM3 out B AA VPW nm1p2_svt_lp W=470e-9 L=60e-9 MR=1
MNM2 AA AN VSS VPW nm1p2_svt_lp W=470n L=60n MR=1
MNM1 AN A VSS VPW nm1p2_svt_lp W=470n L=60n MR=1
MNM0 BN B VSS VPW nm1p2_svt_lp W=940e-9 L=60e-9 MR=1
MPM15 CO net50 VDD VNW pm1p2_svt_lp W=2.36e-6 L=60e-9 MR=1
MPM14 net50 out CN VNW pm1p2_svt_lp W=590e-9 L=60e-9 MR=1
MPM13 net50 outn BN VNW pm1p2_svt_lp W=590e-9 L=60e-9 MR=1
MPM11 S net35 VDD VNW pm1p2_svt_lp W=2.36e-6 L=60e-9 MR=1
MPM10 net35 outn CN VNW pm1p2_svt_lp W=590e-9 L=60e-9 MR=1
MPM9 net35 out CC VNW pm1p2_svt_lp W=590e-9 L=60e-9 MR=1
MPM8 CC CN VDD VNW pm1p2_svt_lp W=1.18e-6 L=60e-9 MR=1
MPM7 CN CI VDD VNW pm1p2_svt_lp W=1.18e-6 L=60e-9 MR=1
MPM5 outn out VDD VNW pm1p2_svt_lp W=590e-9 L=60e-9 MR=1
MPM4 out B AN VNW pm1p2_svt_lp W=590e-9 L=60e-9 MR=1
MPM3 out BN AA VNW pm1p2_svt_lp W=590e-9 L=60e-9 MR=1
MPM2 AA AN VDD VNW pm1p2_svt_lp W=590n L=60n MR=1
MPM1 AN A VDD VNW pm1p2_svt_lp W=590n L=60n MR=1
MPM0 BN B VDD VNW pm1p2_svt_lp W=1.18e-6 L=60e-9 MR=1
.ENDS
.SUBCKT ADDHCINX0P5_9TSVT A CIN CO S VDD VSS VNW VPW
MNM8 CO net32 VSS VPW nm1p2_svt_lp W=230e-9 L=60e-9 MR=1
MNM7 net39 CINN VSS VPW nm1p2_svt_lp W=230e-9 L=60e-9 MR=1
MNM6 net32 A net39 VPW nm1p2_svt_lp W=230e-9 L=60e-9 MR=1
MNM5 S out VSS VPW nm1p2_svt_lp W=230e-9 L=60e-9 MR=1
MNM4 out CINN AA VPW nm1p2_svt_lp W=230e-9 L=60e-9 MR=1
MNM3 out CIN AN VPW nm1p2_svt_lp W=230e-9 L=60e-9 MR=1
MNM2 AA AN VSS VPW nm1p2_svt_lp W=230e-9 L=60e-9 MR=1
MNM1 AN A VSS VPW nm1p2_svt_lp W=230e-9 L=60e-9 MR=1
MNM0 CINN CIN VSS VPW nm1p2_svt_lp W=230e-9 L=60e-9 MR=1
MPM8 CO net32 VDD VNW pm1p2_svt_lp W=300e-9 L=60e-9 MR=1
MPM7 net32 CINN VDD VNW pm1p2_svt_lp W=300e-9 L=60e-9 MR=1
MPM6 net32 A VDD VNW pm1p2_svt_lp W=300e-9 L=60e-9 MR=1
MPM5 S out VDD VNW pm1p2_svt_lp W=300e-9 L=60e-9 MR=1
MPM4 out CIN AA VNW pm1p2_svt_lp W=300e-9 L=60e-9 MR=1
MPM3 out CINN AN VNW pm1p2_svt_lp W=300e-9 L=60e-9 MR=1
MPM2 AA AN VDD VNW pm1p2_svt_lp W=300e-9 L=60e-9 MR=1
MPM1 AN A VDD VNW pm1p2_svt_lp W=300e-9 L=60e-9 MR=1
MPM0 CINN CIN VDD VNW pm1p2_svt_lp W=300e-9 L=60e-9 MR=1
.ENDS
.SUBCKT ADDHCINX1_9TSVT A CIN CO S VDD VSS VNW VPW
MNM8 CO net32 VSS VPW nm1p2_svt_lp W=470e-9 L=60e-9 MR=1
MNM7 net39 CINN VSS VPW nm1p2_svt_lp W=230n L=60n MR=1
MNM6 net32 A net39 VPW nm1p2_svt_lp W=230n L=60n MR=1
MNM5 S out VSS VPW nm1p2_svt_lp W=470e-9 L=60e-9 MR=1
MNM4 out CINN AA VPW nm1p2_svt_lp W=230n L=60n MR=1
MNM3 out CIN AN VPW nm1p2_svt_lp W=230n L=60n MR=1
MNM2 AA AN VSS VPW nm1p2_svt_lp W=230n L=60n MR=1
MNM1 AN A VSS VPW nm1p2_svt_lp W=230n L=60n MR=1
MNM0 CINN CIN VSS VPW nm1p2_svt_lp W=230n L=60n MR=1
MPM8 CO net32 VDD VNW pm1p2_svt_lp W=590e-9 L=60e-9 MR=1
MPM7 net32 CINN VDD VNW pm1p2_svt_lp W=300n L=60n MR=1
MPM6 net32 A VDD VNW pm1p2_svt_lp W=300n L=60n MR=1
MPM5 S out VDD VNW pm1p2_svt_lp W=590e-9 L=60e-9 MR=1
MPM4 out CIN AA VNW pm1p2_svt_lp W=300n L=60n MR=1
MPM3 out CINN AN VNW pm1p2_svt_lp W=300n L=60n MR=1
MPM2 AA AN VDD VNW pm1p2_svt_lp W=300n L=60n MR=1
MPM1 AN A VDD VNW pm1p2_svt_lp W=300n L=60n MR=1
MPM0 CINN CIN VDD VNW pm1p2_svt_lp W=300n L=60n MR=1
.ENDS
.SUBCKT ADDHCINX2_9TSVT A CIN CO S VDD VSS VNW VPW
MNM8 CO net32 VSS VPW nm1p2_svt_lp W=940e-9 L=60e-9 MR=1
MNM7 net39 CINN VSS VPW nm1p2_svt_lp W=470e-9 L=60e-9 MR=1
MNM6 net32 A net39 VPW nm1p2_svt_lp W=470e-9 L=60e-9 MR=1
MNM5 S out VSS VPW nm1p2_svt_lp W=940e-9 L=60e-9 MR=1
MNM4 out CINN AA VPW nm1p2_svt_lp W=230n L=60n MR=1
MNM3 out CIN AN VPW nm1p2_svt_lp W=230n L=60n MR=1
MNM2 AA AN VSS VPW nm1p2_svt_lp W=470e-9 L=60e-9 MR=1
MNM1 AN A VSS VPW nm1p2_svt_lp W=470e-9 L=60e-9 MR=1
MNM0 CINN CIN VSS VPW nm1p2_svt_lp W=230n L=60n MR=1
MPM8 CO net32 VDD VNW pm1p2_svt_lp W=1.18e-6 L=60e-9 MR=1
MPM7 net32 CINN VDD VNW pm1p2_svt_lp W=590e-9 L=60e-9 MR=1
MPM6 net32 A VDD VNW pm1p2_svt_lp W=590e-9 L=60e-9 MR=1
MPM5 S out VDD VNW pm1p2_svt_lp W=1.18e-6 L=60e-9 MR=1
MPM4 out CIN AA VNW pm1p2_svt_lp W=300n L=60n MR=1
MPM3 out CINN AN VNW pm1p2_svt_lp W=300n L=60n MR=1
MPM2 AA AN VDD VNW pm1p2_svt_lp W=590e-9 L=60e-9 MR=1
MPM1 AN A VDD VNW pm1p2_svt_lp W=590e-9 L=60e-9 MR=1
MPM0 CINN CIN VDD VNW pm1p2_svt_lp W=300n L=60n MR=1
.ENDS
.SUBCKT ADDHCINX4_9TSVT A CIN CO S VDD VSS VNW VPW
MNM8 CO net32 VSS VPW nm1p2_svt_lp W=1.88e-6 L=60e-9 MR=1
MNM7 net39 CINN VSS VPW nm1p2_svt_lp W=940e-9 L=60e-9 MR=1
MNM6 net32 A net39 VPW nm1p2_svt_lp W=940e-9 L=60e-9 MR=1
MNM5 S out VSS VPW nm1p2_svt_lp W=1.88e-6 L=60e-9 MR=1
MNM4 out CINN AA VPW nm1p2_svt_lp W=470e-9 L=60e-9 MR=1
MNM3 out CIN AN VPW nm1p2_svt_lp W=470e-9 L=60e-9 MR=1
MNM2 AA AN VSS VPW nm1p2_svt_lp W=940e-9 L=60e-9 MR=1
MNM1 AN A VSS VPW nm1p2_svt_lp W=940e-9 L=60e-9 MR=1
MNM0 CINN CIN VSS VPW nm1p2_svt_lp W=470e-9 L=60e-9 MR=1
MPM8 CO net32 VDD VNW pm1p2_svt_lp W=2.36e-6 L=60e-9 MR=1
MPM7 net32 CINN VDD VNW pm1p2_svt_lp W=1.18e-6 L=60e-9 MR=1
MPM6 net32 A VDD VNW pm1p2_svt_lp W=1.18e-6 L=60e-9 MR=1
MPM5 S out VDD VNW pm1p2_svt_lp W=2.36e-6 L=60e-9 MR=1
MPM4 out CIN AA VNW pm1p2_svt_lp W=590e-9 L=60e-9 MR=1
MPM3 out CINN AN VNW pm1p2_svt_lp W=590e-9 L=60e-9 MR=1
MPM2 AA AN VDD VNW pm1p2_svt_lp W=1.18e-6 L=60e-9 MR=1
MPM1 AN A VDD VNW pm1p2_svt_lp W=1.18e-6 L=60e-9 MR=1
MPM0 CINN CIN VDD VNW pm1p2_svt_lp W=590e-9 L=60e-9 MR=1
.ENDS
.SUBCKT ADDHX0P5_9TSVT A B CO S VDD VSS VNW VPW
MNM8 CO net32 VSS VPW nm1p2_svt_lp W=230e-9 L=60e-9 MR=1
MNM7 net39 B VSS VPW nm1p2_svt_lp W=230e-9 L=60e-9 MR=1
MNM6 net32 A net39 VPW nm1p2_svt_lp W=230e-9 L=60e-9 MR=1
MNM5 S out VSS VPW nm1p2_svt_lp W=230e-9 L=60e-9 MR=1
MNM4 out BN AN VPW nm1p2_svt_lp W=230e-9 L=60e-9 MR=1
MNM3 out B AA VPW nm1p2_svt_lp W=230e-9 L=60e-9 MR=1
MNM2 AA AN VSS VPW nm1p2_svt_lp W=230e-9 L=60e-9 MR=1
MNM1 AN A VSS VPW nm1p2_svt_lp W=230e-9 L=60e-9 MR=1
MNM0 BN B VSS VPW nm1p2_svt_lp W=230e-9 L=60e-9 MR=1
MPM8 CO net32 VDD VNW pm1p2_svt_lp W=300e-9 L=60e-9 MR=1
MPM7 net32 B VDD VNW pm1p2_svt_lp W=300e-9 L=60e-9 MR=1
MPM6 net32 A VDD VNW pm1p2_svt_lp W=300e-9 L=60e-9 MR=1
MPM5 S out VDD VNW pm1p2_svt_lp W=300e-9 L=60e-9 MR=1
MPM4 out B AN VNW pm1p2_svt_lp W=300e-9 L=60e-9 MR=1
MPM3 out BN AA VNW pm1p2_svt_lp W=300e-9 L=60e-9 MR=1
MPM2 AA AN VDD VNW pm1p2_svt_lp W=300e-9 L=60e-9 MR=1
MPM1 AN A VDD VNW pm1p2_svt_lp W=300e-9 L=60e-9 MR=1
MPM0 BN B VDD VNW pm1p2_svt_lp W=300e-9 L=60e-9 MR=1
.ENDS
.SUBCKT ADDHX1_9TSVT A B CO S VDD VSS VNW VPW
MNM8 CO net32 VSS VPW nm1p2_svt_lp W=470e-9 L=60e-9 MR=1
MNM7 net39 B VSS VPW nm1p2_svt_lp W=230n L=60n MR=1
MNM6 net32 A net39 VPW nm1p2_svt_lp W=230n L=60n MR=1
MNM5 S out VSS VPW nm1p2_svt_lp W=470e-9 L=60e-9 MR=1
MNM4 out BN AN VPW nm1p2_svt_lp W=230n L=60n MR=1
MNM3 out B AA VPW nm1p2_svt_lp W=230n L=60n MR=1
MNM2 AA AN VSS VPW nm1p2_svt_lp W=230n L=60n MR=1
MNM1 AN A VSS VPW nm1p2_svt_lp W=230n L=60n MR=1
MNM0 BN B VSS VPW nm1p2_svt_lp W=230n L=60n MR=1
MPM8 CO net32 VDD VNW pm1p2_svt_lp W=590e-9 L=60e-9 MR=1
MPM7 net32 B VDD VNW pm1p2_svt_lp W=300n L=60n MR=1
MPM6 net32 A VDD VNW pm1p2_svt_lp W=300n L=60n MR=1
MPM5 S out VDD VNW pm1p2_svt_lp W=590e-9 L=60e-9 MR=1
MPM4 out B AN VNW pm1p2_svt_lp W=300n L=60n MR=1
MPM3 out BN AA VNW pm1p2_svt_lp W=300n L=60n MR=1
MPM2 AA AN VDD VNW pm1p2_svt_lp W=300n L=60n MR=1
MPM1 AN A VDD VNW pm1p2_svt_lp W=300n L=60n MR=1
MPM0 BN B VDD VNW pm1p2_svt_lp W=300n L=60n MR=1
.ENDS
.SUBCKT ADDHX2_9TSVT A B CO S VDD VSS VNW VPW
MNM8 CO net32 VSS VPW nm1p2_svt_lp W=940e-9 L=60e-9 MR=1
MNM7 net39 B VSS VPW nm1p2_svt_lp W=470e-9 L=60e-9 MR=1
MNM6 net32 A net39 VPW nm1p2_svt_lp W=470e-9 L=60e-9 MR=1
MNM5 S out VSS VPW nm1p2_svt_lp W=940e-9 L=60e-9 MR=1
MNM4 out BN AN VPW nm1p2_svt_lp W=230n L=60n MR=1
MNM3 out B AA VPW nm1p2_svt_lp W=230n L=60n MR=1
MNM2 AA AN VSS VPW nm1p2_svt_lp W=470e-9 L=60e-9 MR=1
MNM1 AN A VSS VPW nm1p2_svt_lp W=470e-9 L=60e-9 MR=1
MNM0 BN B VSS VPW nm1p2_svt_lp W=230n L=60n MR=1
MPM8 CO net32 VDD VNW pm1p2_svt_lp W=1.18e-6 L=60e-9 MR=1
MPM7 net32 B VDD VNW pm1p2_svt_lp W=590e-9 L=60e-9 MR=1
MPM6 net32 A VDD VNW pm1p2_svt_lp W=590e-9 L=60e-9 MR=1
MPM5 S out VDD VNW pm1p2_svt_lp W=1.18e-6 L=60e-9 MR=1
MPM4 out B AN VNW pm1p2_svt_lp W=300n L=60n MR=1
MPM3 out BN AA VNW pm1p2_svt_lp W=300n L=60n MR=1
MPM2 AA AN VDD VNW pm1p2_svt_lp W=590e-9 L=60e-9 MR=1
MPM1 AN A VDD VNW pm1p2_svt_lp W=590e-9 L=60e-9 MR=1
MPM0 BN B VDD VNW pm1p2_svt_lp W=300n L=60n MR=1
.ENDS
.SUBCKT ADDHX4_9TSVT A B CO S VDD VSS VNW VPW
MNM8 CO net32 VSS VPW nm1p2_svt_lp W=1.88e-6 L=60e-9 MR=1
MNM7 net39 B VSS VPW nm1p2_svt_lp W=940e-9 L=60e-9 MR=1
MNM6 net32 A net39 VPW nm1p2_svt_lp W=940e-9 L=60e-9 MR=1
MNM5 S out VSS VPW nm1p2_svt_lp W=1.88e-6 L=60e-9 MR=1
MNM4 out BN AN VPW nm1p2_svt_lp W=470e-9 L=60e-9 MR=1
MNM3 out B AA VPW nm1p2_svt_lp W=470e-9 L=60e-9 MR=1
MNM2 AA AN VSS VPW nm1p2_svt_lp W=940e-9 L=60e-9 MR=1
MNM1 AN A VSS VPW nm1p2_svt_lp W=940e-9 L=60e-9 MR=1
MNM0 BN B VSS VPW nm1p2_svt_lp W=470e-9 L=60e-9 MR=1
MPM8 CO net32 VDD VNW pm1p2_svt_lp W=2.36e-6 L=60e-9 MR=1
MPM7 net32 B VDD VNW pm1p2_svt_lp W=1.18e-6 L=60e-9 MR=1
MPM6 net32 A VDD VNW pm1p2_svt_lp W=1.18e-6 L=60e-9 MR=1
MPM5 S out VDD VNW pm1p2_svt_lp W=2.36e-6 L=60e-9 MR=1
MPM4 out B AN VNW pm1p2_svt_lp W=590e-9 L=60e-9 MR=1
MPM3 out BN AA VNW pm1p2_svt_lp W=590e-9 L=60e-9 MR=1
MPM2 AA AN VDD VNW pm1p2_svt_lp W=1.18e-6 L=60e-9 MR=1
MPM1 AN A VDD VNW pm1p2_svt_lp W=1.18e-6 L=60e-9 MR=1
MPM0 BN B VDD VNW pm1p2_svt_lp W=590e-9 L=60e-9 MR=1
.ENDS
.SUBCKT AND2X0P5_9TSVT A B VDD VSS Y VNW VPW
MNM2 Y net13 VSS VPW nm1p2_svt_lp W=230e-9 L=60e-9 MR=1
MNM1 net19 B VSS VPW nm1p2_svt_lp W=230e-9 L=60e-9 MR=1
MNM0 net13 A net19 VPW nm1p2_svt_lp W=230e-9 L=60e-9 MR=1
MPM2 Y net13 VDD VNW pm1p2_svt_lp W=300e-9 L=60e-9 MR=1
MPM1 net13 B VDD VNW pm1p2_svt_lp W=300e-9 L=60e-9 MR=1
MPM0 net13 A VDD VNW pm1p2_svt_lp W=300e-9 L=60e-9 MR=1
.ENDS
.SUBCKT AND2X1_9TSVT A B VDD VSS Y VNW VPW
MNM2 Y net13 VSS VPW nm1p2_svt_lp W=470e-9 L=60e-9 MR=1
MNM1 net19 B VSS VPW nm1p2_svt_lp W=230e-9 L=60e-9 MR=1
MNM0 net13 A net19 VPW nm1p2_svt_lp W=230e-9 L=60e-9 MR=1
MPM2 Y net13 VDD VNW pm1p2_svt_lp W=590e-9 L=60e-9 MR=1
MPM1 net13 B VDD VNW pm1p2_svt_lp W=300e-9 L=60e-9 MR=1
MPM0 net13 A VDD VNW pm1p2_svt_lp W=300e-9 L=60e-9 MR=1
.ENDS
.SUBCKT AND2X2_9TSVT A B VDD VSS Y VNW VPW
MNM2 Y net13 VSS VPW nm1p2_svt_lp W=940e-9 L=60e-9 MR=1
MNM1 net19 B VSS VPW nm1p2_svt_lp W=470e-9 L=60e-9 MR=1
MNM0 net13 A net19 VPW nm1p2_svt_lp W=470e-9 L=60e-9 MR=1
MPM2 Y net13 VDD VNW pm1p2_svt_lp W=1.18e-6 L=60e-9 MR=1
MPM1 net13 B VDD VNW pm1p2_svt_lp W=590e-9 L=60e-9 MR=1
MPM0 net13 A VDD VNW pm1p2_svt_lp W=590e-9 L=60e-9 MR=1
.ENDS
.SUBCKT AND2X3_9TSVT A B VDD VSS Y VNW VPW
MNM2 Y net13 VSS VPW nm1p2_svt_lp W=1.41e-6 L=60e-9 MR=1
MNM1 net19 B VSS VPW nm1p2_svt_lp W=470e-9 L=60e-9 MR=1
MNM0 net13 A net19 VPW nm1p2_svt_lp W=470e-9 L=60e-9 MR=1
MPM2 Y net13 VDD VNW pm1p2_svt_lp W=1.77e-6 L=60e-9 MR=1
MPM1 net13 B VDD VNW pm1p2_svt_lp W=590e-9 L=60e-9 MR=1
MPM0 net13 A VDD VNW pm1p2_svt_lp W=590e-9 L=60e-9 MR=1
.ENDS
.SUBCKT AND2X4_9TSVT A B VDD VSS Y VNW VPW
MNM2 Y net13 VSS VPW nm1p2_svt_lp W=1.88e-6 L=60e-9 MR=1
MNM1 net19 B VSS VPW nm1p2_svt_lp W=940e-9 L=60e-9 MR=1
MNM0 net13 A net19 VPW nm1p2_svt_lp W=940e-9 L=60e-9 MR=1
MPM2 Y net13 VDD VNW pm1p2_svt_lp W=2.36e-6 L=60e-9 MR=1
MPM1 net13 B VDD VNW pm1p2_svt_lp W=1.18e-6 L=60e-9 MR=1
MPM0 net13 A VDD VNW pm1p2_svt_lp W=1.18e-6 L=60e-9 MR=1
.ENDS
.SUBCKT AND2X6_9TSVT A B VDD VSS Y VNW VPW
MNM2 Y net13 VSS VPW nm1p2_svt_lp W=2.82e-6 L=60e-9 MR=1
MNM1 net19 B VSS VPW nm1p2_svt_lp W=940e-9 L=60e-9 MR=1
MNM0 net13 A net19 VPW nm1p2_svt_lp W=940e-9 L=60e-9 MR=1
MPM2 Y net13 VDD VNW pm1p2_svt_lp W=3.54e-6 L=60e-9 MR=1
MPM1 net13 B VDD VNW pm1p2_svt_lp W=1.18e-6 L=60e-9 MR=1
MPM0 net13 A VDD VNW pm1p2_svt_lp W=1.18e-6 L=60e-9 MR=1
.ENDS
.SUBCKT AND2X8_9TSVT A B VDD VSS Y VNW VPW
MNM2 Y net13 VSS VPW nm1p2_svt_lp W=3.76e-6 L=60e-9 MR=1
MNM1 net19 B VSS VPW nm1p2_svt_lp W=1.41e-6 L=60e-9 MR=1
MNM0 net13 A net19 VPW nm1p2_svt_lp W=1.41e-6 L=60e-9 MR=1
MPM2 Y net13 VDD VNW pm1p2_svt_lp W=4.72e-6 L=60e-9 MR=1
MPM1 net13 B VDD VNW pm1p2_svt_lp W=1.77e-6 L=60e-9 MR=1
MPM0 net13 A VDD VNW pm1p2_svt_lp W=1.77e-6 L=60e-9 MR=1
.ENDS
.SUBCKT AND3X0P5_9TSVT A B C VDD VSS Y VNW VPW
MNM3 Y net17 VSS VPW nm1p2_svt_lp W=230e-9 L=60e-9 MR=1
MNM2 net24 C VSS VPW nm1p2_svt_lp W=230e-9 L=60e-9 MR=1
MNM1 net25 B net24 VPW nm1p2_svt_lp W=230e-9 L=60e-9 MR=1
MNM0 net17 A net25 VPW nm1p2_svt_lp W=230e-9 L=60e-9 MR=1
MPM3 Y net17 VDD VNW pm1p2_svt_lp W=300e-9 L=60e-9 MR=1
MPM2 net17 C VDD VNW pm1p2_svt_lp W=300e-9 L=60e-9 MR=1
MPM1 net17 B VDD VNW pm1p2_svt_lp W=300e-9 L=60e-9 MR=1
MPM0 net17 A VDD VNW pm1p2_svt_lp W=300e-9 L=60e-9 MR=1
.ENDS
.SUBCKT AND3X1_9TSVT A B C VDD VSS Y VNW VPW
MNM3 Y net17 VSS VPW nm1p2_svt_lp W=470e-9 L=60e-9 MR=1
MNM2 net24 C VSS VPW nm1p2_svt_lp W=230e-9 L=60e-9 MR=1
MNM1 net25 B net24 VPW nm1p2_svt_lp W=230e-9 L=60e-9 MR=1
MNM0 net17 A net25 VPW nm1p2_svt_lp W=230e-9 L=60e-9 MR=1
MPM3 Y net17 VDD VNW pm1p2_svt_lp W=590e-9 L=60e-9 MR=1
MPM2 net17 C VDD VNW pm1p2_svt_lp W=300e-9 L=60e-9 MR=1
MPM1 net17 B VDD VNW pm1p2_svt_lp W=300e-9 L=60e-9 MR=1
MPM0 net17 A VDD VNW pm1p2_svt_lp W=300e-9 L=60e-9 MR=1
.ENDS
.SUBCKT AND3X2_9TSVT A B C VDD VSS Y VNW VPW
MNM3 Y net17 VSS VPW nm1p2_svt_lp W=940e-9 L=60e-9 MR=1
MNM2 net24 C VSS VPW nm1p2_svt_lp W=470e-9 L=60e-9 MR=1
MNM1 net25 B net24 VPW nm1p2_svt_lp W=470e-9 L=60e-9 MR=1
MNM0 net17 A net25 VPW nm1p2_svt_lp W=470e-9 L=60e-9 MR=1
MPM3 Y net17 VDD VNW pm1p2_svt_lp W=1.18e-6 L=60e-9 MR=1
MPM2 net17 C VDD VNW pm1p2_svt_lp W=590e-9 L=60e-9 MR=1
MPM1 net17 B VDD VNW pm1p2_svt_lp W=590e-9 L=60e-9 MR=1
MPM0 net17 A VDD VNW pm1p2_svt_lp W=590e-9 L=60e-9 MR=1
.ENDS
.SUBCKT AND3X3_9TSVT A B C VDD VSS Y VNW VPW
MNM3 Y net17 VSS VPW nm1p2_svt_lp W=1.41e-6 L=60e-9 MR=1
MNM2 net24 C VSS VPW nm1p2_svt_lp W=470e-9 L=60e-9 MR=1
MNM1 net25 B net24 VPW nm1p2_svt_lp W=470e-9 L=60e-9 MR=1
MNM0 net17 A net25 VPW nm1p2_svt_lp W=470e-9 L=60e-9 MR=1
MPM3 Y net17 VDD VNW pm1p2_svt_lp W=1.77e-6 L=60e-9 MR=1
MPM2 net17 C VDD VNW pm1p2_svt_lp W=590e-9 L=60e-9 MR=1
MPM1 net17 B VDD VNW pm1p2_svt_lp W=590e-9 L=60e-9 MR=1
MPM0 net17 A VDD VNW pm1p2_svt_lp W=590e-9 L=60e-9 MR=1
.ENDS
.SUBCKT AND3X4_9TSVT A B C VDD VSS Y VNW VPW
MNM3 Y net17 VSS VPW nm1p2_svt_lp W=1.88e-6 L=60e-9 MR=1
MNM2 net24 C VSS VPW nm1p2_svt_lp W=940e-9 L=60e-9 MR=1
MNM1 net25 B net24 VPW nm1p2_svt_lp W=940e-9 L=60e-9 MR=1
MNM0 net17 A net25 VPW nm1p2_svt_lp W=940e-9 L=60e-9 MR=1
MPM3 Y net17 VDD VNW pm1p2_svt_lp W=2.36e-6 L=60e-9 MR=1
MPM2 net17 C VDD VNW pm1p2_svt_lp W=1.18e-6 L=60e-9 MR=1
MPM1 net17 B VDD VNW pm1p2_svt_lp W=1.18e-6 L=60e-9 MR=1
MPM0 net17 A VDD VNW pm1p2_svt_lp W=1.18e-6 L=60e-9 MR=1
.ENDS
.SUBCKT AND3X6_9TSVT A B C VDD VSS Y VNW VPW
MNM3 Y net17 VSS VPW nm1p2_svt_lp W=2.82e-6 L=60e-9 MR=1
MNM2 net24 C VSS VPW nm1p2_svt_lp W=940e-9 L=60e-9 MR=1
MNM1 net25 B net24 VPW nm1p2_svt_lp W=940e-9 L=60e-9 MR=1
MNM0 net17 A net25 VPW nm1p2_svt_lp W=940e-9 L=60e-9 MR=1
MPM3 Y net17 VDD VNW pm1p2_svt_lp W=3.54e-6 L=60e-9 MR=1
MPM2 net17 C VDD VNW pm1p2_svt_lp W=1.18e-6 L=60e-9 MR=1
MPM1 net17 B VDD VNW pm1p2_svt_lp W=1.18e-6 L=60e-9 MR=1
MPM0 net17 A VDD VNW pm1p2_svt_lp W=1.18e-6 L=60e-9 MR=1
.ENDS
.SUBCKT AND3X8_9TSVT A B C VDD VSS Y VNW VPW
MNM3 Y net17 VSS VPW nm1p2_svt_lp W=3.76e-6 L=60e-9 MR=1
MNM2 net24 C VSS VPW nm1p2_svt_lp W=1.41e-6 L=60e-9 MR=1
MNM1 net25 B net24 VPW nm1p2_svt_lp W=1.41e-6 L=60e-9 MR=1
MNM0 net17 A net25 VPW nm1p2_svt_lp W=1.41e-6 L=60e-9 MR=1
MPM3 Y net17 VDD VNW pm1p2_svt_lp W=4.72e-6 L=60e-9 MR=1
MPM2 net17 C VDD VNW pm1p2_svt_lp W=1.77e-6 L=60e-9 MR=1
MPM1 net17 B VDD VNW pm1p2_svt_lp W=1.77e-6 L=60e-9 MR=1
MPM0 net17 A VDD VNW pm1p2_svt_lp W=1.77e-6 L=60e-9 MR=1
.ENDS
.SUBCKT AND4X0P5_9TSVT A B C D VDD VSS Y VNW VPW
MNM4 Y net19 VSS VPW nm1p2_svt_lp W=230e-9 L=60e-9 MR=1
MNM3 net27 D VSS VPW nm1p2_svt_lp W=230e-9 L=60e-9 MR=1
MNM2 net28 C net27 VPW nm1p2_svt_lp W=230e-9 L=60e-9 MR=1
MNM1 net29 B net28 VPW nm1p2_svt_lp W=230e-9 L=60e-9 MR=1
MNM0 net19 A net29 VPW nm1p2_svt_lp W=230e-9 L=60e-9 MR=1
MPM4 Y net19 VDD VNW pm1p2_svt_lp W=300e-9 L=60e-9 MR=1
MPM3 net19 D VDD VNW pm1p2_svt_lp W=300e-9 L=60e-9 MR=1
MPM2 net19 C VDD VNW pm1p2_svt_lp W=300e-9 L=60e-9 MR=1
MPM1 net19 B VDD VNW pm1p2_svt_lp W=300e-9 L=60e-9 MR=1
MPM0 net19 A VDD VNW pm1p2_svt_lp W=300e-9 L=60e-9 MR=1
.ENDS
.SUBCKT AND4X1_9TSVT A B C D VDD VSS Y VNW VPW
MNM4 Y net19 VSS VPW nm1p2_svt_lp W=470e-9 L=60e-9 MR=1
MNM3 net27 D VSS VPW nm1p2_svt_lp W=230e-9 L=60e-9 MR=1
MNM2 net28 C net27 VPW nm1p2_svt_lp W=230e-9 L=60e-9 MR=1
MNM1 net29 B net28 VPW nm1p2_svt_lp W=230e-9 L=60e-9 MR=1
MNM0 net19 A net29 VPW nm1p2_svt_lp W=230e-9 L=60e-9 MR=1
MPM4 Y net19 VDD VNW pm1p2_svt_lp W=590e-9 L=60e-9 MR=1
MPM3 net19 D VDD VNW pm1p2_svt_lp W=300e-9 L=60e-9 MR=1
MPM2 net19 C VDD VNW pm1p2_svt_lp W=300e-9 L=60e-9 MR=1
MPM1 net19 B VDD VNW pm1p2_svt_lp W=300e-9 L=60e-9 MR=1
MPM0 net19 A VDD VNW pm1p2_svt_lp W=300e-9 L=60e-9 MR=1
.ENDS
.SUBCKT AND4X2_9TSVT A B C D VDD VSS Y VNW VPW
MNM4 Y net19 VSS VPW nm1p2_svt_lp W=940e-9 L=60e-9 MR=1
MNM3 net27 D VSS VPW nm1p2_svt_lp W=470e-9 L=60e-9 MR=1
MNM2 net28 C net27 VPW nm1p2_svt_lp W=470e-9 L=60e-9 MR=1
MNM1 net29 B net28 VPW nm1p2_svt_lp W=470e-9 L=60e-9 MR=1
MNM0 net19 A net29 VPW nm1p2_svt_lp W=470e-9 L=60e-9 MR=1
MPM4 Y net19 VDD VNW pm1p2_svt_lp W=1.18e-6 L=60e-9 MR=1
MPM3 net19 D VDD VNW pm1p2_svt_lp W=590e-9 L=60e-9 MR=1
MPM2 net19 C VDD VNW pm1p2_svt_lp W=590e-9 L=60e-9 MR=1
MPM1 net19 B VDD VNW pm1p2_svt_lp W=590e-9 L=60e-9 MR=1
MPM0 net19 A VDD VNW pm1p2_svt_lp W=590e-9 L=60e-9 MR=1
.ENDS
.SUBCKT AND4X3_9TSVT A B C D VDD VSS Y VNW VPW
MNM4 Y net19 VSS VPW nm1p2_svt_lp W=1.41e-6 L=60e-9 MR=1
MNM3 net27 D VSS VPW nm1p2_svt_lp W=470e-9 L=60e-9 MR=1
MNM2 net28 C net27 VPW nm1p2_svt_lp W=470e-9 L=60e-9 MR=1
MNM1 net29 B net28 VPW nm1p2_svt_lp W=470e-9 L=60e-9 MR=1
MNM0 net19 A net29 VPW nm1p2_svt_lp W=470e-9 L=60e-9 MR=1
MPM4 Y net19 VDD VNW pm1p2_svt_lp W=1.77e-6 L=60e-9 MR=1
MPM3 net19 D VDD VNW pm1p2_svt_lp W=590e-9 L=60e-9 MR=1
MPM2 net19 C VDD VNW pm1p2_svt_lp W=590e-9 L=60e-9 MR=1
MPM1 net19 B VDD VNW pm1p2_svt_lp W=590e-9 L=60e-9 MR=1
MPM0 net19 A VDD VNW pm1p2_svt_lp W=590e-9 L=60e-9 MR=1
.ENDS
.SUBCKT AND4X4_9TSVT A B C D VDD VSS Y VNW VPW
MNM4 Y net19 VSS VPW nm1p2_svt_lp W=1.88e-6 L=60e-9 MR=1
MNM3 net27 D VSS VPW nm1p2_svt_lp W=940e-9 L=60e-9 MR=1
MNM2 net28 C net27 VPW nm1p2_svt_lp W=940e-9 L=60e-9 MR=1
MNM1 net29 B net28 VPW nm1p2_svt_lp W=940e-9 L=60e-9 MR=1
MNM0 net19 A net29 VPW nm1p2_svt_lp W=940e-9 L=60e-9 MR=1
MPM4 Y net19 VDD VNW pm1p2_svt_lp W=2.36e-6 L=60e-9 MR=1
MPM3 net19 D VDD VNW pm1p2_svt_lp W=1.18e-6 L=60e-9 MR=1
MPM2 net19 C VDD VNW pm1p2_svt_lp W=1.18e-6 L=60e-9 MR=1
MPM1 net19 B VDD VNW pm1p2_svt_lp W=1.18e-6 L=60e-9 MR=1
MPM0 net19 A VDD VNW pm1p2_svt_lp W=1.18e-6 L=60e-9 MR=1
.ENDS
.SUBCKT AND4X6_9TSVT A B C D VDD VSS Y VNW VPW
MNM4 Y net19 VSS VPW nm1p2_svt_lp W=2.82e-6 L=60e-9 MR=1
MNM3 net27 D VSS VPW nm1p2_svt_lp W=940e-9 L=60e-9 MR=1
MNM2 net28 C net27 VPW nm1p2_svt_lp W=940e-9 L=60e-9 MR=1
MNM1 net29 B net28 VPW nm1p2_svt_lp W=940e-9 L=60e-9 MR=1
MNM0 net19 A net29 VPW nm1p2_svt_lp W=940e-9 L=60e-9 MR=1
MPM4 Y net19 VDD VNW pm1p2_svt_lp W=3.54e-6 L=60e-9 MR=1
MPM3 net19 D VDD VNW pm1p2_svt_lp W=1.18e-6 L=60e-9 MR=1
MPM2 net19 C VDD VNW pm1p2_svt_lp W=1.18e-6 L=60e-9 MR=1
MPM1 net19 B VDD VNW pm1p2_svt_lp W=1.18e-6 L=60e-9 MR=1
MPM0 net19 A VDD VNW pm1p2_svt_lp W=1.18e-6 L=60e-9 MR=1
.ENDS
.SUBCKT AND4X8_9TSVT A B C D VDD VSS Y VNW VPW
MNM4 Y net19 VSS VPW nm1p2_svt_lp W=3.76e-6 L=60e-9 MR=1
MNM3 net27 D VSS VPW nm1p2_svt_lp W=1.41e-6 L=60e-9 MR=1
MNM2 net28 C net27 VPW nm1p2_svt_lp W=1.41e-6 L=60e-9 MR=1
MNM1 net29 B net28 VPW nm1p2_svt_lp W=1.41e-6 L=60e-9 MR=1
MNM0 net19 A net29 VPW nm1p2_svt_lp W=1.41e-6 L=60e-9 MR=1
MPM4 Y net19 VDD VNW pm1p2_svt_lp W=4.72e-6 L=60e-9 MR=1
MPM3 net19 D VDD VNW pm1p2_svt_lp W=1.77e-6 L=60e-9 MR=1
MPM2 net19 C VDD VNW pm1p2_svt_lp W=1.77e-6 L=60e-9 MR=1
MPM1 net19 B VDD VNW pm1p2_svt_lp W=1.77e-6 L=60e-9 MR=1
MPM0 net19 A VDD VNW pm1p2_svt_lp W=1.77e-6 L=60e-9 MR=1
.ENDS
.SUBCKT ANTENNAX1_9TSVT A VDD VSS VNW VPW
DD0 VPW A dio_1p2_np_pw_lp AREA=0.054p PJ=1.02u m=1
.ENDS
.SUBCKT AO211X0P5_9TSVT A0 A1 B0 C0 VDD VSS Y VNW VPW
MNM4 Y net18 VSS VPW nm1p2_svt_lp W=230e-9 L=60e-9 MR=1
MNM3 net18 C0 VSS VPW nm1p2_svt_lp W=230e-9 L=60e-9 MR=1
MNM2 net18 B0 VSS VPW nm1p2_svt_lp W=230e-9 L=60e-9 MR=1
MNM1 net26 A1 VSS VPW nm1p2_svt_lp W=230e-9 L=60e-9 MR=1
MNM0 net18 A0 net26 VPW nm1p2_svt_lp W=230e-9 L=60e-9 MR=1
MPM4 Y net18 VDD VNW pm1p2_svt_lp W=300e-9 L=60e-9 MR=1
MPM3 net25 C0 VDD VNW pm1p2_svt_lp W=300e-9 L=60e-9 MR=1
MPM2 net17 B0 net25 VNW pm1p2_svt_lp W=300e-9 L=60e-9 MR=1
MPM1 net18 A1 net17 VNW pm1p2_svt_lp W=300e-9 L=60e-9 MR=1
MPM0 net18 A0 net17 VNW pm1p2_svt_lp W=300e-9 L=60e-9 MR=1
.ENDS
.SUBCKT AO211X1_9TSVT A0 A1 B0 C0 VDD VSS Y VNW VPW
MNM4 Y net18 VSS VPW nm1p2_svt_lp W=470e-9 L=60e-9 MR=1
MNM3 net18 C0 VSS VPW nm1p2_svt_lp W=470e-9 L=60e-9 MR=1
MNM2 net18 B0 VSS VPW nm1p2_svt_lp W=470e-9 L=60e-9 MR=1
MNM1 net26 A1 VSS VPW nm1p2_svt_lp W=470e-9 L=60e-9 MR=1
MNM0 net18 A0 net26 VPW nm1p2_svt_lp W=470e-9 L=60e-9 MR=1
MPM4 Y net18 VDD VNW pm1p2_svt_lp W=590e-9 L=60e-9 MR=1
MPM3 net25 C0 VDD VNW pm1p2_svt_lp W=590e-9 L=60e-9 MR=1
MPM2 net17 B0 net25 VNW pm1p2_svt_lp W=590e-9 L=60e-9 MR=1
MPM1 net18 A1 net17 VNW pm1p2_svt_lp W=590e-9 L=60e-9 MR=1
MPM0 net18 A0 net17 VNW pm1p2_svt_lp W=590e-9 L=60e-9 MR=1
.ENDS
.SUBCKT AO211X2_9TSVT A0 A1 B0 C0 VDD VSS Y VNW VPW
MNM4 Y net18 VSS VPW nm1p2_svt_lp W=940e-9 L=60e-9 MR=1
MNM3 net18 C0 VSS VPW nm1p2_svt_lp W=470e-9 L=60e-9 MR=1
MNM2 net18 B0 VSS VPW nm1p2_svt_lp W=470e-9 L=60e-9 MR=1
MNM1 net26 A1 VSS VPW nm1p2_svt_lp W=470e-9 L=60e-9 MR=1
MNM0 net18 A0 net26 VPW nm1p2_svt_lp W=470e-9 L=60e-9 MR=1
MPM4 Y net18 VDD VNW pm1p2_svt_lp W=1.18e-6 L=60e-9 MR=1
MPM3 net25 C0 VDD VNW pm1p2_svt_lp W=590e-9 L=60e-9 MR=1
MPM2 net17 B0 net25 VNW pm1p2_svt_lp W=590e-9 L=60e-9 MR=1
MPM1 net18 A1 net17 VNW pm1p2_svt_lp W=590e-9 L=60e-9 MR=1
MPM0 net18 A0 net17 VNW pm1p2_svt_lp W=590e-9 L=60e-9 MR=1
.ENDS
.SUBCKT AO211X4_9TSVT A0 A1 B0 C0 VDD VSS Y VNW VPW
MNM4 Y net18 VSS VPW nm1p2_svt_lp W=1.88e-6 L=60e-9 MR=1
MNM3 net18 C0 VSS VPW nm1p2_svt_lp W=940e-9 L=60e-9 MR=1
MNM2 net18 B0 VSS VPW nm1p2_svt_lp W=940e-9 L=60e-9 MR=1
MNM1 net26 A1 VSS VPW nm1p2_svt_lp W=940e-9 L=60e-9 MR=1
MNM0 net18 A0 net26 VPW nm1p2_svt_lp W=940e-9 L=60e-9 MR=1
MPM4 Y net18 VDD VNW pm1p2_svt_lp W=2.36e-6 L=60e-9 MR=1
MPM3 net25 C0 VDD VNW pm1p2_svt_lp W=1.18e-6 L=60e-9 MR=1
MPM2 net17 B0 net25 VNW pm1p2_svt_lp W=1.18e-6 L=60e-9 MR=1
MPM1 net18 A1 net17 VNW pm1p2_svt_lp W=1.18e-6 L=60e-9 MR=1
MPM0 net18 A0 net17 VNW pm1p2_svt_lp W=1.18e-6 L=60e-9 MR=1
.ENDS
.SUBCKT AO21X0P5_9TSVT A0 A1 B0 VDD VSS Y VNW VPW
MNM3 Y net16 VSS VPW nm1p2_svt_lp W=230e-9 L=60e-9 MR=1
MNM2 net16 B0 VSS VPW nm1p2_svt_lp W=230e-9 L=60e-9 MR=1
MNM1 net22 A1 VSS VPW nm1p2_svt_lp W=230e-9 L=60e-9 MR=1
MNM0 net16 A0 net22 VPW nm1p2_svt_lp W=230e-9 L=60e-9 MR=1
MPM3 Y net16 VDD VNW pm1p2_svt_lp W=300e-9 L=60e-9 MR=1
MPM2 net15 B0 VDD VNW pm1p2_svt_lp W=300e-9 L=60e-9 MR=1
MPM1 net16 A1 net15 VNW pm1p2_svt_lp W=300e-9 L=60e-9 MR=1
MPM0 net16 A0 net15 VNW pm1p2_svt_lp W=300e-9 L=60e-9 MR=1
.ENDS
.SUBCKT AO21X1_9TSVT A0 A1 B0 VDD VSS Y VNW VPW
MNM3 Y net16 VSS VPW nm1p2_svt_lp W=470e-9 L=60e-9 MR=1
MNM2 net16 B0 VSS VPW nm1p2_svt_lp W=470e-9 L=60e-9 MR=1
MNM1 net22 A1 VSS VPW nm1p2_svt_lp W=470e-9 L=60e-9 MR=1
MNM0 net16 A0 net22 VPW nm1p2_svt_lp W=470e-9 L=60e-9 MR=1
MPM3 Y net16 VDD VNW pm1p2_svt_lp W=590e-9 L=60e-9 MR=1
MPM2 net15 B0 VDD VNW pm1p2_svt_lp W=590e-9 L=60e-9 MR=1
MPM1 net16 A1 net15 VNW pm1p2_svt_lp W=590e-9 L=60e-9 MR=1
MPM0 net16 A0 net15 VNW pm1p2_svt_lp W=590e-9 L=60e-9 MR=1
.ENDS
.SUBCKT AO21X2_9TSVT A0 A1 B0 VDD VSS Y VNW VPW
MNM3 Y net16 VSS VPW nm1p2_svt_lp W=940e-9 L=60e-9 MR=1
MNM2 net16 B0 VSS VPW nm1p2_svt_lp W=470e-9 L=60e-9 MR=1
MNM1 net22 A1 VSS VPW nm1p2_svt_lp W=470e-9 L=60e-9 MR=1
MNM0 net16 A0 net22 VPW nm1p2_svt_lp W=470e-9 L=60e-9 MR=1
MPM3 Y net16 VDD VNW pm1p2_svt_lp W=1.18e-6 L=60e-9 MR=1
MPM2 net15 B0 VDD VNW pm1p2_svt_lp W=590e-9 L=60e-9 MR=1
MPM1 net16 A1 net15 VNW pm1p2_svt_lp W=590e-9 L=60e-9 MR=1
MPM0 net16 A0 net15 VNW pm1p2_svt_lp W=590e-9 L=60e-9 MR=1
.ENDS
.SUBCKT AO21X4_9TSVT A0 A1 B0 VDD VSS Y VNW VPW
MNM3 Y net16 VSS VPW nm1p2_svt_lp W=1.88e-6 L=60e-9 MR=1
MNM2 net16 B0 VSS VPW nm1p2_svt_lp W=940e-9 L=60e-9 MR=1
MNM1 net22 A1 VSS VPW nm1p2_svt_lp W=940e-9 L=60e-9 MR=1
MNM0 net16 A0 net22 VPW nm1p2_svt_lp W=940e-9 L=60e-9 MR=1
MPM3 Y net16 VDD VNW pm1p2_svt_lp W=2.36e-6 L=60e-9 MR=1
MPM2 net15 B0 VDD VNW pm1p2_svt_lp W=1.18e-6 L=60e-9 MR=1
MPM1 net16 A1 net15 VNW pm1p2_svt_lp W=1.18e-6 L=60e-9 MR=1
MPM0 net16 A0 net15 VNW pm1p2_svt_lp W=1.18e-6 L=60e-9 MR=1
.ENDS
.SUBCKT AO221X0P5_9TSVT A0 A1 B0 B1 C0 VDD VSS Y VNW VPW
MNM5 Y net21 VSS VPW nm1p2_svt_lp W=230e-9 L=60e-9 MR=1
MNM4 net21 C0 VSS VPW nm1p2_svt_lp W=230e-9 L=60e-9 MR=1
MNM3 net31 B1 VSS VPW nm1p2_svt_lp W=230e-9 L=60e-9 MR=1
MNM2 net21 B0 net31 VPW nm1p2_svt_lp W=230e-9 L=60e-9 MR=1
MNM1 net32 A1 VSS VPW nm1p2_svt_lp W=230e-9 L=60e-9 MR=1
MNM0 net21 A0 net32 VPW nm1p2_svt_lp W=230e-9 L=60e-9 MR=1
MPM5 Y net21 VDD VNW pm1p2_svt_lp W=300e-9 L=60e-9 MR=1
MPM4 net20 C0 VDD VNW pm1p2_svt_lp W=300e-9 L=60e-9 MR=1
MPM3 net19 B1 net20 VNW pm1p2_svt_lp W=300e-9 L=60e-9 MR=1
MPM2 net19 B0 net20 VNW pm1p2_svt_lp W=300e-9 L=60e-9 MR=1
MPM1 net21 A1 net19 VNW pm1p2_svt_lp W=300e-9 L=60e-9 MR=1
MPM0 net21 A0 net19 VNW pm1p2_svt_lp W=300e-9 L=60e-9 MR=1
.ENDS
.SUBCKT AO221X1_9TSVT A0 A1 B0 B1 C0 VDD VSS Y VNW VPW
MNM5 Y net21 VSS VPW nm1p2_svt_lp W=470e-9 L=60e-9 MR=1
MNM4 net21 C0 VSS VPW nm1p2_svt_lp W=470e-9 L=60e-9 MR=1
MNM3 net31 B1 VSS VPW nm1p2_svt_lp W=470e-9 L=60e-9 MR=1
MNM2 net21 B0 net31 VPW nm1p2_svt_lp W=470e-9 L=60e-9 MR=1
MNM1 net32 A1 VSS VPW nm1p2_svt_lp W=470e-9 L=60e-9 MR=1
MNM0 net21 A0 net32 VPW nm1p2_svt_lp W=470e-9 L=60e-9 MR=1
MPM5 Y net21 VDD VNW pm1p2_svt_lp W=590e-9 L=60e-9 MR=1
MPM4 net20 C0 VDD VNW pm1p2_svt_lp W=590e-9 L=60e-9 MR=1
MPM3 net19 B1 net20 VNW pm1p2_svt_lp W=590e-9 L=60e-9 MR=1
MPM2 net19 B0 net20 VNW pm1p2_svt_lp W=590e-9 L=60e-9 MR=1
MPM1 net21 A1 net19 VNW pm1p2_svt_lp W=590e-9 L=60e-9 MR=1
MPM0 net21 A0 net19 VNW pm1p2_svt_lp W=590e-9 L=60e-9 MR=1
.ENDS
.SUBCKT AO221X2_9TSVT A0 A1 B0 B1 C0 VDD VSS Y VNW VPW
MNM5 Y net21 VSS VPW nm1p2_svt_lp W=940e-9 L=60e-9 MR=1
MNM4 net21 C0 VSS VPW nm1p2_svt_lp W=470e-9 L=60e-9 MR=1
MNM3 net31 B1 VSS VPW nm1p2_svt_lp W=470e-9 L=60e-9 MR=1
MNM2 net21 B0 net31 VPW nm1p2_svt_lp W=470e-9 L=60e-9 MR=1
MNM1 net32 A1 VSS VPW nm1p2_svt_lp W=470e-9 L=60e-9 MR=1
MNM0 net21 A0 net32 VPW nm1p2_svt_lp W=470e-9 L=60e-9 MR=1
MPM5 Y net21 VDD VNW pm1p2_svt_lp W=1.18e-6 L=60e-9 MR=1
MPM4 net20 C0 VDD VNW pm1p2_svt_lp W=590e-9 L=60e-9 MR=1
MPM3 net19 B1 net20 VNW pm1p2_svt_lp W=590e-9 L=60e-9 MR=1
MPM2 net19 B0 net20 VNW pm1p2_svt_lp W=590e-9 L=60e-9 MR=1
MPM1 net21 A1 net19 VNW pm1p2_svt_lp W=590e-9 L=60e-9 MR=1
MPM0 net21 A0 net19 VNW pm1p2_svt_lp W=590e-9 L=60e-9 MR=1
.ENDS
.SUBCKT AO221X4_9TSVT A0 A1 B0 B1 C0 VDD VSS Y VNW VPW
MNM5 Y net21 VSS VPW nm1p2_svt_lp W=1.88e-6 L=60e-9 MR=1
MNM4 net21 C0 VSS VPW nm1p2_svt_lp W=940e-9 L=60e-9 MR=1
MNM3 net31 B1 VSS VPW nm1p2_svt_lp W=940e-9 L=60e-9 MR=1
MNM2 net21 B0 net31 VPW nm1p2_svt_lp W=940e-9 L=60e-9 MR=1
MNM1 net32 A1 VSS VPW nm1p2_svt_lp W=940e-9 L=60e-9 MR=1
MNM0 net21 A0 net32 VPW nm1p2_svt_lp W=940e-9 L=60e-9 MR=1
MPM5 Y net21 VDD VNW pm1p2_svt_lp W=2.36e-6 L=60e-9 MR=1
MPM4 net20 C0 VDD VNW pm1p2_svt_lp W=1.18e-6 L=60e-9 MR=1
MPM3 net19 B1 net20 VNW pm1p2_svt_lp W=1.18e-6 L=60e-9 MR=1
MPM2 net19 B0 net20 VNW pm1p2_svt_lp W=1.18e-6 L=60e-9 MR=1
MPM1 net21 A1 net19 VNW pm1p2_svt_lp W=1.18e-6 L=60e-9 MR=1
MPM0 net21 A0 net19 VNW pm1p2_svt_lp W=1.18e-6 L=60e-9 MR=1
.ENDS
.SUBCKT AO222X0P5_9TSVT A0 A1 B0 B1 C0 C1 VDD VSS Y VNW VPW
MNM6 Y net23 VSS VPW nm1p2_svt_lp W=230e-9 L=60e-9 MR=1
MNM5 net34 C1 VSS VPW nm1p2_svt_lp W=230e-9 L=60e-9 MR=1
MNM4 net23 C0 net34 VPW nm1p2_svt_lp W=230e-9 L=60e-9 MR=1
MNM3 net35 B1 VSS VPW nm1p2_svt_lp W=230e-9 L=60e-9 MR=1
MNM2 net23 B0 net35 VPW nm1p2_svt_lp W=230e-9 L=60e-9 MR=1
MNM1 net36 A1 VSS VPW nm1p2_svt_lp W=230e-9 L=60e-9 MR=1
MNM0 net23 A0 net36 VPW nm1p2_svt_lp W=230e-9 L=60e-9 MR=1
MPM6 Y net23 VDD VNW pm1p2_svt_lp W=300e-9 L=60e-9 MR=1
MPM5 net22 C1 VDD VNW pm1p2_svt_lp W=300e-9 L=60e-9 MR=1
MPM4 net22 C0 VDD VNW pm1p2_svt_lp W=300e-9 L=60e-9 MR=1
MPM3 net21 B1 net22 VNW pm1p2_svt_lp W=300e-9 L=60e-9 MR=1
MPM2 net21 B0 net22 VNW pm1p2_svt_lp W=300e-9 L=60e-9 MR=1
MPM1 net23 A1 net21 VNW pm1p2_svt_lp W=300e-9 L=60e-9 MR=1
MPM0 net23 A0 net21 VNW pm1p2_svt_lp W=300e-9 L=60e-9 MR=1
.ENDS
.SUBCKT AO222X1_9TSVT A0 A1 B0 B1 C0 C1 VDD VSS Y VNW VPW
MNM6 Y net23 VSS VPW nm1p2_svt_lp W=470e-9 L=60e-9 MR=1
MNM5 net34 C1 VSS VPW nm1p2_svt_lp W=470e-9 L=60e-9 MR=1
MNM4 net23 C0 net34 VPW nm1p2_svt_lp W=470e-9 L=60e-9 MR=1
MNM3 net35 B1 VSS VPW nm1p2_svt_lp W=470e-9 L=60e-9 MR=1
MNM2 net23 B0 net35 VPW nm1p2_svt_lp W=470e-9 L=60e-9 MR=1
MNM1 net36 A1 VSS VPW nm1p2_svt_lp W=470e-9 L=60e-9 MR=1
MNM0 net23 A0 net36 VPW nm1p2_svt_lp W=470e-9 L=60e-9 MR=1
MPM6 Y net23 VDD VNW pm1p2_svt_lp W=590e-9 L=60e-9 MR=1
MPM5 net22 C1 VDD VNW pm1p2_svt_lp W=590e-9 L=60e-9 MR=1
MPM4 net22 C0 VDD VNW pm1p2_svt_lp W=590e-9 L=60e-9 MR=1
MPM3 net21 B1 net22 VNW pm1p2_svt_lp W=590e-9 L=60e-9 MR=1
MPM2 net21 B0 net22 VNW pm1p2_svt_lp W=590e-9 L=60e-9 MR=1
MPM1 net23 A1 net21 VNW pm1p2_svt_lp W=590e-9 L=60e-9 MR=1
MPM0 net23 A0 net21 VNW pm1p2_svt_lp W=590e-9 L=60e-9 MR=1
.ENDS
.SUBCKT AO222X2_9TSVT A0 A1 B0 B1 C0 C1 VDD VSS Y VNW VPW
MNM6 Y net23 VSS VPW nm1p2_svt_lp W=940e-9 L=60e-9 MR=1
MNM5 net34 C1 VSS VPW nm1p2_svt_lp W=470e-9 L=60e-9 MR=1
MNM4 net23 C0 net34 VPW nm1p2_svt_lp W=470e-9 L=60e-9 MR=1
MNM3 net35 B1 VSS VPW nm1p2_svt_lp W=470e-9 L=60e-9 MR=1
MNM2 net23 B0 net35 VPW nm1p2_svt_lp W=470e-9 L=60e-9 MR=1
MNM1 net36 A1 VSS VPW nm1p2_svt_lp W=470e-9 L=60e-9 MR=1
MNM0 net23 A0 net36 VPW nm1p2_svt_lp W=470e-9 L=60e-9 MR=1
MPM6 Y net23 VDD VNW pm1p2_svt_lp W=1.18e-6 L=60e-9 MR=1
MPM5 net22 C1 VDD VNW pm1p2_svt_lp W=590e-9 L=60e-9 MR=1
MPM4 net22 C0 VDD VNW pm1p2_svt_lp W=590e-9 L=60e-9 MR=1
MPM3 net21 B1 net22 VNW pm1p2_svt_lp W=590e-9 L=60e-9 MR=1
MPM2 net21 B0 net22 VNW pm1p2_svt_lp W=590e-9 L=60e-9 MR=1
MPM1 net23 A1 net21 VNW pm1p2_svt_lp W=590e-9 L=60e-9 MR=1
MPM0 net23 A0 net21 VNW pm1p2_svt_lp W=590e-9 L=60e-9 MR=1
.ENDS
.SUBCKT AO222X4_9TSVT A0 A1 B0 B1 C0 C1 VDD VSS Y VNW VPW
MNM6 Y net23 VSS VPW nm1p2_svt_lp W=1.88e-6 L=60e-9 MR=1
MNM5 net34 C1 VSS VPW nm1p2_svt_lp W=940e-9 L=60e-9 MR=1
MNM4 net23 C0 net34 VPW nm1p2_svt_lp W=940e-9 L=60e-9 MR=1
MNM3 net35 B1 VSS VPW nm1p2_svt_lp W=940e-9 L=60e-9 MR=1
MNM2 net23 B0 net35 VPW nm1p2_svt_lp W=940e-9 L=60e-9 MR=1
MNM1 net36 A1 VSS VPW nm1p2_svt_lp W=940e-9 L=60e-9 MR=1
MNM0 net23 A0 net36 VPW nm1p2_svt_lp W=940e-9 L=60e-9 MR=1
MPM6 Y net23 VDD VNW pm1p2_svt_lp W=2.36e-6 L=60e-9 MR=1
MPM5 net22 C1 VDD VNW pm1p2_svt_lp W=1.18e-6 L=60e-9 MR=1
MPM4 net22 C0 VDD VNW pm1p2_svt_lp W=1.18e-6 L=60e-9 MR=1
MPM3 net21 B1 net22 VNW pm1p2_svt_lp W=1.18e-6 L=60e-9 MR=1
MPM2 net21 B0 net22 VNW pm1p2_svt_lp W=1.18e-6 L=60e-9 MR=1
MPM1 net23 A1 net21 VNW pm1p2_svt_lp W=1.18e-6 L=60e-9 MR=1
MPM0 net23 A0 net21 VNW pm1p2_svt_lp W=1.18e-6 L=60e-9 MR=1
.ENDS
.SUBCKT AO22X0P5_9TSVT A0 A1 B0 B1 VDD VSS Y VNW VPW
MNM4 Y net18 VSS VPW nm1p2_svt_lp W=230e-9 L=60e-9 MR=1
MNM3 net26 B1 VSS VPW nm1p2_svt_lp W=230e-9 L=60e-9 MR=1
MNM2 net18 B0 net26 VPW nm1p2_svt_lp W=230e-9 L=60e-9 MR=1
MNM1 net27 A1 VSS VPW nm1p2_svt_lp W=230e-9 L=60e-9 MR=1
MNM0 net18 A0 net27 VPW nm1p2_svt_lp W=230e-9 L=60e-9 MR=1
MPM4 Y net18 VDD VNW pm1p2_svt_lp W=300e-9 L=60e-9 MR=1
MPM3 net17 B1 VDD VNW pm1p2_svt_lp W=300e-9 L=60e-9 MR=1
MPM2 net17 B0 VDD VNW pm1p2_svt_lp W=300e-9 L=60e-9 MR=1
MPM1 net18 A1 net17 VNW pm1p2_svt_lp W=300e-9 L=60e-9 MR=1
MPM0 net18 A0 net17 VNW pm1p2_svt_lp W=300e-9 L=60e-9 MR=1
.ENDS
.SUBCKT AO22X1_9TSVT A0 A1 B0 B1 VDD VSS Y VNW VPW
MNM4 Y net18 VSS VPW nm1p2_svt_lp W=470e-9 L=60e-9 MR=1
MNM3 net26 B1 VSS VPW nm1p2_svt_lp W=470e-9 L=60e-9 MR=1
MNM2 net18 B0 net26 VPW nm1p2_svt_lp W=470e-9 L=60e-9 MR=1
MNM1 net27 A1 VSS VPW nm1p2_svt_lp W=470e-9 L=60e-9 MR=1
MNM0 net18 A0 net27 VPW nm1p2_svt_lp W=470e-9 L=60e-9 MR=1
MPM4 Y net18 VDD VNW pm1p2_svt_lp W=590e-9 L=60e-9 MR=1
MPM3 net17 B1 VDD VNW pm1p2_svt_lp W=590e-9 L=60e-9 MR=1
MPM2 net17 B0 VDD VNW pm1p2_svt_lp W=590e-9 L=60e-9 MR=1
MPM1 net18 A1 net17 VNW pm1p2_svt_lp W=590e-9 L=60e-9 MR=1
MPM0 net18 A0 net17 VNW pm1p2_svt_lp W=590e-9 L=60e-9 MR=1
.ENDS
.SUBCKT AO22X2_9TSVT A0 A1 B0 B1 VDD VSS Y VNW VPW
MNM4 Y net18 VSS VPW nm1p2_svt_lp W=940e-9 L=60e-9 MR=1
MNM3 net26 B1 VSS VPW nm1p2_svt_lp W=470e-9 L=60e-9 MR=1
MNM2 net18 B0 net26 VPW nm1p2_svt_lp W=470e-9 L=60e-9 MR=1
MNM1 net27 A1 VSS VPW nm1p2_svt_lp W=470e-9 L=60e-9 MR=1
MNM0 net18 A0 net27 VPW nm1p2_svt_lp W=470e-9 L=60e-9 MR=1
MPM4 Y net18 VDD VNW pm1p2_svt_lp W=1.18e-6 L=60e-9 MR=1
MPM3 net17 B1 VDD VNW pm1p2_svt_lp W=590e-9 L=60e-9 MR=1
MPM2 net17 B0 VDD VNW pm1p2_svt_lp W=590e-9 L=60e-9 MR=1
MPM1 net18 A1 net17 VNW pm1p2_svt_lp W=590e-9 L=60e-9 MR=1
MPM0 net18 A0 net17 VNW pm1p2_svt_lp W=590e-9 L=60e-9 MR=1
.ENDS
.SUBCKT AO22X4_9TSVT A0 A1 B0 B1 VDD VSS Y VNW VPW
MNM4 Y net18 VSS VPW nm1p2_svt_lp W=1.88e-6 L=60e-9 MR=1
MNM3 net26 B1 VSS VPW nm1p2_svt_lp W=940e-9 L=60e-9 MR=1
MNM2 net18 B0 net26 VPW nm1p2_svt_lp W=940e-9 L=60e-9 MR=1
MNM1 net27 A1 VSS VPW nm1p2_svt_lp W=940e-9 L=60e-9 MR=1
MNM0 net18 A0 net27 VPW nm1p2_svt_lp W=940e-9 L=60e-9 MR=1
MPM4 Y net18 VDD VNW pm1p2_svt_lp W=2.36e-6 L=60e-9 MR=1
MPM3 net17 B1 VDD VNW pm1p2_svt_lp W=1.18e-6 L=60e-9 MR=1
MPM2 net17 B0 VDD VNW pm1p2_svt_lp W=1.18e-6 L=60e-9 MR=1
MPM1 net18 A1 net17 VNW pm1p2_svt_lp W=1.18e-6 L=60e-9 MR=1
MPM0 net18 A0 net17 VNW pm1p2_svt_lp W=1.18e-6 L=60e-9 MR=1
.ENDS
.SUBCKT AO31X0P5_9TSVT A0 A1 A2 B0 VDD VSS Y VNW VPW
MNM4 Y net19 VSS VPW nm1p2_svt_lp W=230e-9 L=60e-9 MR=1
MNM3 net19 B0 VSS VPW nm1p2_svt_lp W=230e-9 L=60e-9 MR=1
MNM2 net26 A2 VSS VPW nm1p2_svt_lp W=230e-9 L=60e-9 MR=1
MNM1 net27 A1 net26 VPW nm1p2_svt_lp W=230e-9 L=60e-9 MR=1
MNM0 net19 A0 net27 VPW nm1p2_svt_lp W=230e-9 L=60e-9 MR=1
MPM4 Y net19 VDD VNW pm1p2_svt_lp W=300e-9 L=60e-9 MR=1
MPM3 net21 B0 VDD VNW pm1p2_svt_lp W=300e-9 L=60e-9 MR=1
MPM2 net19 A2 net21 VNW pm1p2_svt_lp W=300e-9 L=60e-9 MR=1
MPM1 net19 A1 net21 VNW pm1p2_svt_lp W=300e-9 L=60e-9 MR=1
MPM0 net19 A0 net21 VNW pm1p2_svt_lp W=300e-9 L=60e-9 MR=1
.ENDS
.SUBCKT AO31X1_9TSVT A0 A1 A2 B0 VDD VSS Y VNW VPW
MNM4 Y net19 VSS VPW nm1p2_svt_lp W=470e-9 L=60e-9 MR=1
MNM3 net19 B0 VSS VPW nm1p2_svt_lp W=470e-9 L=60e-9 MR=1
MNM2 net26 A2 VSS VPW nm1p2_svt_lp W=470e-9 L=60e-9 MR=1
MNM1 net27 A1 net26 VPW nm1p2_svt_lp W=470e-9 L=60e-9 MR=1
MNM0 net19 A0 net27 VPW nm1p2_svt_lp W=470e-9 L=60e-9 MR=1
MPM4 Y net19 VDD VNW pm1p2_svt_lp W=590e-9 L=60e-9 MR=1
MPM3 net21 B0 VDD VNW pm1p2_svt_lp W=590e-9 L=60e-9 MR=1
MPM2 net19 A2 net21 VNW pm1p2_svt_lp W=590e-9 L=60e-9 MR=1
MPM1 net19 A1 net21 VNW pm1p2_svt_lp W=590e-9 L=60e-9 MR=1
MPM0 net19 A0 net21 VNW pm1p2_svt_lp W=590e-9 L=60e-9 MR=1
.ENDS
.SUBCKT AO31X2_9TSVT A0 A1 A2 B0 VDD VSS Y VNW VPW
MNM4 Y net19 VSS VPW nm1p2_svt_lp W=940e-9 L=60e-9 MR=1
MNM3 net19 B0 VSS VPW nm1p2_svt_lp W=470e-9 L=60e-9 MR=1
MNM2 net26 A2 VSS VPW nm1p2_svt_lp W=470e-9 L=60e-9 MR=1
MNM1 net27 A1 net26 VPW nm1p2_svt_lp W=470e-9 L=60e-9 MR=1
MNM0 net19 A0 net27 VPW nm1p2_svt_lp W=470e-9 L=60e-9 MR=1
MPM4 Y net19 VDD VNW pm1p2_svt_lp W=1.18e-6 L=60e-9 MR=1
MPM3 net21 B0 VDD VNW pm1p2_svt_lp W=590e-9 L=60e-9 MR=1
MPM2 net19 A2 net21 VNW pm1p2_svt_lp W=590e-9 L=60e-9 MR=1
MPM1 net19 A1 net21 VNW pm1p2_svt_lp W=590e-9 L=60e-9 MR=1
MPM0 net19 A0 net21 VNW pm1p2_svt_lp W=590e-9 L=60e-9 MR=1
.ENDS
.SUBCKT AO31X4_9TSVT A0 A1 A2 B0 VDD VSS Y VNW VPW
MNM4 Y net19 VSS VPW nm1p2_svt_lp W=1.88e-6 L=60e-9 MR=1
MNM3 net19 B0 VSS VPW nm1p2_svt_lp W=940e-9 L=60e-9 MR=1
MNM2 net26 A2 VSS VPW nm1p2_svt_lp W=940e-9 L=60e-9 MR=1
MNM1 net27 A1 net26 VPW nm1p2_svt_lp W=940e-9 L=60e-9 MR=1
MNM0 net19 A0 net27 VPW nm1p2_svt_lp W=940e-9 L=60e-9 MR=1
MPM4 Y net19 VDD VNW pm1p2_svt_lp W=2.36e-6 L=60e-9 MR=1
MPM3 net21 B0 VDD VNW pm1p2_svt_lp W=1.18e-6 L=60e-9 MR=1
MPM2 net19 A2 net21 VNW pm1p2_svt_lp W=1.18e-6 L=60e-9 MR=1
MPM1 net19 A1 net21 VNW pm1p2_svt_lp W=1.18e-6 L=60e-9 MR=1
MPM0 net19 A0 net21 VNW pm1p2_svt_lp W=1.18e-6 L=60e-9 MR=1
.ENDS
.SUBCKT AO32X0P5_9TSVT A0 A1 A2 B0 B1 VDD VSS Y VNW VPW
MNM5 Y net21 VSS VPW nm1p2_svt_lp W=230e-9 L=60e-9 MR=1
MNM4 net30 B1 VSS VPW nm1p2_svt_lp W=230e-9 L=60e-9 MR=1
MNM3 net21 B0 net30 VPW nm1p2_svt_lp W=230e-9 L=60e-9 MR=1
MNM2 net31 A2 VSS VPW nm1p2_svt_lp W=230e-9 L=60e-9 MR=1
MNM1 net32 A1 net31 VPW nm1p2_svt_lp W=230e-9 L=60e-9 MR=1
MNM0 net21 A0 net32 VPW nm1p2_svt_lp W=230e-9 L=60e-9 MR=1
MPM5 Y net21 VDD VNW pm1p2_svt_lp W=300e-9 L=60e-9 MR=1
MPM4 net19 B1 VDD VNW pm1p2_svt_lp W=300e-9 L=60e-9 MR=1
MPM3 net19 B0 VDD VNW pm1p2_svt_lp W=300e-9 L=60e-9 MR=1
MPM2 net21 A2 net19 VNW pm1p2_svt_lp W=300e-9 L=60e-9 MR=1
MPM1 net21 A1 net19 VNW pm1p2_svt_lp W=300e-9 L=60e-9 MR=1
MPM0 net21 A0 net19 VNW pm1p2_svt_lp W=300e-9 L=60e-9 MR=1
.ENDS
.SUBCKT AO32X1_9TSVT A0 A1 A2 B0 B1 VDD VSS Y VNW VPW
MNM5 Y net21 VSS VPW nm1p2_svt_lp W=470e-9 L=60e-9 MR=1
MNM4 net30 B1 VSS VPW nm1p2_svt_lp W=470e-9 L=60e-9 MR=1
MNM3 net21 B0 net30 VPW nm1p2_svt_lp W=470e-9 L=60e-9 MR=1
MNM2 net31 A2 VSS VPW nm1p2_svt_lp W=470e-9 L=60e-9 MR=1
MNM1 net32 A1 net31 VPW nm1p2_svt_lp W=470e-9 L=60e-9 MR=1
MNM0 net21 A0 net32 VPW nm1p2_svt_lp W=470e-9 L=60e-9 MR=1
MPM5 Y net21 VDD VNW pm1p2_svt_lp W=590e-9 L=60e-9 MR=1
MPM4 net19 B1 VDD VNW pm1p2_svt_lp W=590e-9 L=60e-9 MR=1
MPM3 net19 B0 VDD VNW pm1p2_svt_lp W=590e-9 L=60e-9 MR=1
MPM2 net21 A2 net19 VNW pm1p2_svt_lp W=590e-9 L=60e-9 MR=1
MPM1 net21 A1 net19 VNW pm1p2_svt_lp W=590e-9 L=60e-9 MR=1
MPM0 net21 A0 net19 VNW pm1p2_svt_lp W=590e-9 L=60e-9 MR=1
.ENDS
.SUBCKT AO32X2_9TSVT A0 A1 A2 B0 B1 VDD VSS Y VNW VPW
MNM5 Y net21 VSS VPW nm1p2_svt_lp W=940e-9 L=60e-9 MR=1
MNM4 net30 B1 VSS VPW nm1p2_svt_lp W=470e-9 L=60e-9 MR=1
MNM3 net21 B0 net30 VPW nm1p2_svt_lp W=470e-9 L=60e-9 MR=1
MNM2 net31 A2 VSS VPW nm1p2_svt_lp W=470e-9 L=60e-9 MR=1
MNM1 net32 A1 net31 VPW nm1p2_svt_lp W=470e-9 L=60e-9 MR=1
MNM0 net21 A0 net32 VPW nm1p2_svt_lp W=470e-9 L=60e-9 MR=1
MPM5 Y net21 VDD VNW pm1p2_svt_lp W=1.18e-6 L=60e-9 MR=1
MPM4 net19 B1 VDD VNW pm1p2_svt_lp W=590e-9 L=60e-9 MR=1
MPM3 net19 B0 VDD VNW pm1p2_svt_lp W=590e-9 L=60e-9 MR=1
MPM2 net21 A2 net19 VNW pm1p2_svt_lp W=590e-9 L=60e-9 MR=1
MPM1 net21 A1 net19 VNW pm1p2_svt_lp W=590e-9 L=60e-9 MR=1
MPM0 net21 A0 net19 VNW pm1p2_svt_lp W=590e-9 L=60e-9 MR=1
.ENDS
.SUBCKT AO32X4_9TSVT A0 A1 A2 B0 B1 VDD VSS Y VNW VPW
MNM5 Y net21 VSS VPW nm1p2_svt_lp W=1.88e-6 L=60e-9 MR=1
MNM4 net30 B1 VSS VPW nm1p2_svt_lp W=940e-9 L=60e-9 MR=1
MNM3 net21 B0 net30 VPW nm1p2_svt_lp W=940e-9 L=60e-9 MR=1
MNM2 net31 A2 VSS VPW nm1p2_svt_lp W=940e-9 L=60e-9 MR=1
MNM1 net32 A1 net31 VPW nm1p2_svt_lp W=940e-9 L=60e-9 MR=1
MNM0 net21 A0 net32 VPW nm1p2_svt_lp W=940e-9 L=60e-9 MR=1
MPM5 Y net21 VDD VNW pm1p2_svt_lp W=2.36e-6 L=60e-9 MR=1
MPM4 net19 B1 VDD VNW pm1p2_svt_lp W=1.18e-6 L=60e-9 MR=1
MPM3 net19 B0 VDD VNW pm1p2_svt_lp W=1.18e-6 L=60e-9 MR=1
MPM2 net21 A2 net19 VNW pm1p2_svt_lp W=1.18e-6 L=60e-9 MR=1
MPM1 net21 A1 net19 VNW pm1p2_svt_lp W=1.18e-6 L=60e-9 MR=1
MPM0 net21 A0 net19 VNW pm1p2_svt_lp W=1.18e-6 L=60e-9 MR=1
.ENDS
.SUBCKT AO33X0P5_9TSVT A0 A1 A2 B0 B1 B2 VDD VSS Y VNW VPW
MNM6 Y net23 VSS VPW nm1p2_svt_lp W=230e-9 L=60e-9 MR=1
MNM5 net34 B2 VSS VPW nm1p2_svt_lp W=230e-9 L=60e-9 MR=1
MNM4 net35 B1 net34 VPW nm1p2_svt_lp W=230e-9 L=60e-9 MR=1
MNM3 net23 B0 net35 VPW nm1p2_svt_lp W=230e-9 L=60e-9 MR=1
MNM2 net36 A2 VSS VPW nm1p2_svt_lp W=230e-9 L=60e-9 MR=1
MNM1 net37 A1 net36 VPW nm1p2_svt_lp W=230e-9 L=60e-9 MR=1
MNM0 net23 A0 net37 VPW nm1p2_svt_lp W=230e-9 L=60e-9 MR=1
MPM6 Y net23 VDD VNW pm1p2_svt_lp W=300e-9 L=60e-9 MR=1
MPM5 net21 B2 VDD VNW pm1p2_svt_lp W=300e-9 L=60e-9 MR=1
MPM4 net21 B1 VDD VNW pm1p2_svt_lp W=300e-9 L=60e-9 MR=1
MPM3 net21 B0 VDD VNW pm1p2_svt_lp W=300e-9 L=60e-9 MR=1
MPM2 net23 A2 net21 VNW pm1p2_svt_lp W=300e-9 L=60e-9 MR=1
MPM1 net23 A1 net21 VNW pm1p2_svt_lp W=300e-9 L=60e-9 MR=1
MPM0 net23 A0 net21 VNW pm1p2_svt_lp W=300e-9 L=60e-9 MR=1
.ENDS
.SUBCKT AO33X1_9TSVT A0 A1 A2 B0 B1 B2 VDD VSS Y VNW VPW
MNM6 Y net23 VSS VPW nm1p2_svt_lp W=470e-9 L=60e-9 MR=1
MNM5 net34 B2 VSS VPW nm1p2_svt_lp W=470e-9 L=60e-9 MR=1
MNM4 net35 B1 net34 VPW nm1p2_svt_lp W=470e-9 L=60e-9 MR=1
MNM3 net23 B0 net35 VPW nm1p2_svt_lp W=470e-9 L=60e-9 MR=1
MNM2 net36 A2 VSS VPW nm1p2_svt_lp W=470e-9 L=60e-9 MR=1
MNM1 net37 A1 net36 VPW nm1p2_svt_lp W=470e-9 L=60e-9 MR=1
MNM0 net23 A0 net37 VPW nm1p2_svt_lp W=470e-9 L=60e-9 MR=1
MPM6 Y net23 VDD VNW pm1p2_svt_lp W=590e-9 L=60e-9 MR=1
MPM5 net21 B2 VDD VNW pm1p2_svt_lp W=590e-9 L=60e-9 MR=1
MPM4 net21 B1 VDD VNW pm1p2_svt_lp W=590e-9 L=60e-9 MR=1
MPM3 net21 B0 VDD VNW pm1p2_svt_lp W=590e-9 L=60e-9 MR=1
MPM2 net23 A2 net21 VNW pm1p2_svt_lp W=590e-9 L=60e-9 MR=1
MPM1 net23 A1 net21 VNW pm1p2_svt_lp W=590e-9 L=60e-9 MR=1
MPM0 net23 A0 net21 VNW pm1p2_svt_lp W=590e-9 L=60e-9 MR=1
.ENDS
.SUBCKT AO33X2_9TSVT A0 A1 A2 B0 B1 B2 VDD VSS Y VNW VPW
MNM6 Y net23 VSS VPW nm1p2_svt_lp W=940e-9 L=60e-9 MR=1
MNM5 net34 B2 VSS VPW nm1p2_svt_lp W=470e-9 L=60e-9 MR=1
MNM4 net35 B1 net34 VPW nm1p2_svt_lp W=470e-9 L=60e-9 MR=1
MNM3 net23 B0 net35 VPW nm1p2_svt_lp W=470e-9 L=60e-9 MR=1
MNM2 net36 A2 VSS VPW nm1p2_svt_lp W=470e-9 L=60e-9 MR=1
MNM1 net37 A1 net36 VPW nm1p2_svt_lp W=470e-9 L=60e-9 MR=1
MNM0 net23 A0 net37 VPW nm1p2_svt_lp W=470e-9 L=60e-9 MR=1
MPM6 Y net23 VDD VNW pm1p2_svt_lp W=1.18e-6 L=60e-9 MR=1
MPM5 net21 B2 VDD VNW pm1p2_svt_lp W=590e-9 L=60e-9 MR=1
MPM4 net21 B1 VDD VNW pm1p2_svt_lp W=590e-9 L=60e-9 MR=1
MPM3 net21 B0 VDD VNW pm1p2_svt_lp W=590e-9 L=60e-9 MR=1
MPM2 net23 A2 net21 VNW pm1p2_svt_lp W=590e-9 L=60e-9 MR=1
MPM1 net23 A1 net21 VNW pm1p2_svt_lp W=590e-9 L=60e-9 MR=1
MPM0 net23 A0 net21 VNW pm1p2_svt_lp W=590e-9 L=60e-9 MR=1
.ENDS
.SUBCKT AO33X4_9TSVT A0 A1 A2 B0 B1 B2 VDD VSS Y VNW VPW
MNM6 Y net23 VSS VPW nm1p2_svt_lp W=1.88e-6 L=60e-9 MR=1
MNM5 net34 B2 VSS VPW nm1p2_svt_lp W=940e-9 L=60e-9 MR=1
MNM4 net35 B1 net34 VPW nm1p2_svt_lp W=940e-9 L=60e-9 MR=1
MNM3 net23 B0 net35 VPW nm1p2_svt_lp W=940e-9 L=60e-9 MR=1
MNM2 net36 A2 VSS VPW nm1p2_svt_lp W=940e-9 L=60e-9 MR=1
MNM1 net37 A1 net36 VPW nm1p2_svt_lp W=940e-9 L=60e-9 MR=1
MNM0 net23 A0 net37 VPW nm1p2_svt_lp W=940e-9 L=60e-9 MR=1
MPM6 Y net23 VDD VNW pm1p2_svt_lp W=2.36e-6 L=60e-9 MR=1
MPM5 net21 B2 VDD VNW pm1p2_svt_lp W=1.18e-6 L=60e-9 MR=1
MPM4 net21 B1 VDD VNW pm1p2_svt_lp W=1.18e-6 L=60e-9 MR=1
MPM3 net21 B0 VDD VNW pm1p2_svt_lp W=1.18e-6 L=60e-9 MR=1
MPM2 net23 A2 net21 VNW pm1p2_svt_lp W=1.18e-6 L=60e-9 MR=1
MPM1 net23 A1 net21 VNW pm1p2_svt_lp W=1.18e-6 L=60e-9 MR=1
MPM0 net23 A0 net21 VNW pm1p2_svt_lp W=1.18e-6 L=60e-9 MR=1
.ENDS
.SUBCKT AOI211X0P5_9TSVT A0 A1 B0 C0 VDD VSS Y VNW VPW
MNM3 Y C0 VSS VPW nm1p2_svt_lp W=230e-9 L=60e-9 MR=1
MNM2 Y B0 VSS VPW nm1p2_svt_lp W=230e-9 L=60e-9 MR=1
MNM1 net23 A1 VSS VPW nm1p2_svt_lp W=230e-9 L=60e-9 MR=1
MNM0 Y A0 net23 VPW nm1p2_svt_lp W=230e-9 L=60e-9 MR=1
MPM3 net22 C0 VDD VNW pm1p2_svt_lp W=300e-9 L=60e-9 MR=1
MPM2 net17 B0 net22 VNW pm1p2_svt_lp W=300e-9 L=60e-9 MR=1
MPM1 Y A1 net17 VNW pm1p2_svt_lp W=300e-9 L=60e-9 MR=1
MPM0 Y A0 net17 VNW pm1p2_svt_lp W=300e-9 L=60e-9 MR=1
.ENDS
.SUBCKT AOI211X1_9TSVT A0 A1 B0 C0 VDD VSS Y VNW VPW
MNM3 Y C0 VSS VPW nm1p2_svt_lp W=470e-9 L=60e-9 MR=1
MNM2 Y B0 VSS VPW nm1p2_svt_lp W=470e-9 L=60e-9 MR=1
MNM1 net23 A1 VSS VPW nm1p2_svt_lp W=470e-9 L=60e-9 MR=1
MNM0 Y A0 net23 VPW nm1p2_svt_lp W=470e-9 L=60e-9 MR=1
MPM3 net22 C0 VDD VNW pm1p2_svt_lp W=590e-9 L=60e-9 MR=1
MPM2 net17 B0 net22 VNW pm1p2_svt_lp W=590e-9 L=60e-9 MR=1
MPM1 Y A1 net17 VNW pm1p2_svt_lp W=590e-9 L=60e-9 MR=1
MPM0 Y A0 net17 VNW pm1p2_svt_lp W=590e-9 L=60e-9 MR=1
.ENDS
.SUBCKT AOI211X2_9TSVT A0 A1 B0 C0 VDD VSS Y VNW VPW
MNM3 Y C0 VSS VPW nm1p2_svt_lp W=940e-9 L=60e-9 MR=1
MNM2 Y B0 VSS VPW nm1p2_svt_lp W=940e-9 L=60e-9 MR=1
MNM1 net23 A1 VSS VPW nm1p2_svt_lp W=940e-9 L=60e-9 MR=1
MNM0 Y A0 net23 VPW nm1p2_svt_lp W=940e-9 L=60e-9 MR=1
MPM3 net22 C0 VDD VNW pm1p2_svt_lp W=1.18e-6 L=60e-9 MR=1
MPM2 net17 B0 net22 VNW pm1p2_svt_lp W=1.18e-6 L=60e-9 MR=1
MPM1 Y A1 net17 VNW pm1p2_svt_lp W=1.18e-6 L=60e-9 MR=1
MPM0 Y A0 net17 VNW pm1p2_svt_lp W=1.18e-6 L=60e-9 MR=1
.ENDS
.SUBCKT AOI211X4_9TSVT A0 A1 B0 C0 VDD VSS Y VNW VPW
MM3 Y net016 VSS VPW nm1p2_svt_lp W=1.88u L=60n MR=1
MM0 net016 net011 VSS VPW nm1p2_svt_lp W=940n L=60n MR=1
MNM3 net011 C0 VSS VPW nm1p2_svt_lp W=470n L=60n MR=1
MNM2 net011 B0 VSS VPW nm1p2_svt_lp W=470n L=60n MR=1
MNM1 net23 A1 VSS VPW nm1p2_svt_lp W=470n L=60n MR=1
MNM0 net011 A0 net23 VPW nm1p2_svt_lp W=470n L=60n MR=1
MM2 Y net016 VDD VNW pm1p2_svt_lp W=2.36u L=60n MR=1
MM1 net016 net011 VDD VNW pm1p2_svt_lp W=1.18u L=60n MR=1
MPM3 net22 C0 VDD VNW pm1p2_svt_lp W=590n L=60n MR=1
MPM2 net17 B0 net22 VNW pm1p2_svt_lp W=590n L=60n MR=1
MPM1 net011 A1 net17 VNW pm1p2_svt_lp W=590n L=60n MR=1
MPM0 net011 A0 net17 VNW pm1p2_svt_lp W=590n L=60n MR=1
.ENDS
.SUBCKT AOI21BBX0P5_9TSVT AN0 AN1 B0 VDD VSS Y VNW VPW
MPM3 Y B0 net21 VNW pm1p2_svt_lp W=300e-9 L=60e-9 MR=1
MPM2 net21 net14 VDD VNW pm1p2_svt_lp W=300e-9 L=60e-9 MR=1
MPM1 net22 AN1 VDD VNW pm1p2_svt_lp W=300e-9 L=60e-9 MR=1
MPM0 net14 AN0 net22 VNW pm1p2_svt_lp W=300e-9 L=60e-9 MR=1
MNM3 Y B0 VSS VPW nm1p2_svt_lp W=230e-9 L=60e-9 MR=1
MNM2 Y net14 VSS VPW nm1p2_svt_lp W=230e-9 L=60e-9 MR=1
MNM1 net14 AN1 VSS VPW nm1p2_svt_lp W=230e-9 L=60e-9 MR=1
MNM0 net14 AN0 VSS VPW nm1p2_svt_lp W=230e-9 L=60e-9 MR=1
.ENDS
.SUBCKT AOI21BBX1_9TSVT AN0 AN1 B0 VDD VSS Y VNW VPW
MPM3 Y B0 net21 VNW pm1p2_svt_lp W=590e-9 L=60e-9 MR=1
MPM2 net21 net14 VDD VNW pm1p2_svt_lp W=590e-9 L=60e-9 MR=1
MPM1 net22 AN1 VDD VNW pm1p2_svt_lp W=300n L=60n MR=1
MPM0 net14 AN0 net22 VNW pm1p2_svt_lp W=300n L=60n MR=1
MNM3 Y B0 VSS VPW nm1p2_svt_lp W=470e-9 L=60e-9 MR=1
MNM2 Y net14 VSS VPW nm1p2_svt_lp W=470e-9 L=60e-9 MR=1
MNM1 net14 AN1 VSS VPW nm1p2_svt_lp W=230n L=60n MR=1
MNM0 net14 AN0 VSS VPW nm1p2_svt_lp W=230n L=60n MR=1
.ENDS
.SUBCKT AOI21BBX2_9TSVT AN0 AN1 B0 VDD VSS Y VNW VPW
MPM3 Y B0 net21 VNW pm1p2_svt_lp W=1.18e-6 L=60e-9 MR=1
MPM2 net21 net14 VDD VNW pm1p2_svt_lp W=1.18e-6 L=60e-9 MR=1
MPM1 net22 AN1 VDD VNW pm1p2_svt_lp W=590e-9 L=60e-9 MR=1
MPM0 net14 AN0 net22 VNW pm1p2_svt_lp W=590e-9 L=60e-9 MR=1
MNM3 Y B0 VSS VPW nm1p2_svt_lp W=940e-9 L=60e-9 MR=1
MNM2 Y net14 VSS VPW nm1p2_svt_lp W=940e-9 L=60e-9 MR=1
MNM1 net14 AN1 VSS VPW nm1p2_svt_lp W=470e-9 L=60e-9 MR=1
MNM0 net14 AN0 VSS VPW nm1p2_svt_lp W=470e-9 L=60e-9 MR=1
.ENDS
.SUBCKT AOI21BBX4_9TSVT AN0 AN1 B0 VDD VSS Y VNW VPW
MM3 Y net016 VDD VNW pm1p2_svt_lp W=2.36u L=60n MR=1
MM1 net016 net020 VDD VNW pm1p2_svt_lp W=1.18u L=60n MR=1
MPM3 net020 B0 net21 VNW pm1p2_svt_lp W=590n L=60n MR=1
MPM2 net21 net14 VDD VNW pm1p2_svt_lp W=590n L=60n MR=1
MPM1 net22 AN1 VDD VNW pm1p2_svt_lp W=300n L=60n MR=1
MPM0 net14 AN0 net22 VNW pm1p2_svt_lp W=300n L=60n MR=1
MM2 Y net016 VSS VPW nm1p2_svt_lp W=1.88u L=60n MR=1
MM0 net016 net020 VSS VPW nm1p2_svt_lp W=940n L=60n MR=1
MNM3 net020 B0 VSS VPW nm1p2_svt_lp W=470n L=60n MR=1
MNM2 net020 net14 VSS VPW nm1p2_svt_lp W=470n L=60n MR=1
MNM1 net14 AN1 VSS VPW nm1p2_svt_lp W=230n L=60n MR=1
MNM0 net14 AN0 VSS VPW nm1p2_svt_lp W=230n L=60n MR=1
.ENDS
.SUBCKT AOI21X0P5_9TSVT A0 A1 B0 VDD VSS Y VNW VPW
MNM2 Y B0 VSS VPW nm1p2_svt_lp W=230e-9 L=60e-9 MR=1
MNM1 net19 A1 VSS VPW nm1p2_svt_lp W=230e-9 L=60e-9 MR=1
MNM0 Y A0 net19 VPW nm1p2_svt_lp W=230e-9 L=60e-9 MR=1
MPM2 net15 B0 VDD VNW pm1p2_svt_lp W=300e-9 L=60e-9 MR=1
MPM1 Y A1 net15 VNW pm1p2_svt_lp W=300e-9 L=60e-9 MR=1
MPM0 Y A0 net15 VNW pm1p2_svt_lp W=300e-9 L=60e-9 MR=1
.ENDS
.SUBCKT AOI21X1_9TSVT A0 A1 B0 VDD VSS Y VNW VPW
MNM2 Y B0 VSS VPW nm1p2_svt_lp W=470e-9 L=60e-9 MR=1
MNM1 net19 A1 VSS VPW nm1p2_svt_lp W=470e-9 L=60e-9 MR=1
MNM0 Y A0 net19 VPW nm1p2_svt_lp W=470e-9 L=60e-9 MR=1
MPM2 net15 B0 VDD VNW pm1p2_svt_lp W=590e-9 L=60e-9 MR=1
MPM1 Y A1 net15 VNW pm1p2_svt_lp W=590e-9 L=60e-9 MR=1
MPM0 Y A0 net15 VNW pm1p2_svt_lp W=590e-9 L=60e-9 MR=1
.ENDS
.SUBCKT AOI21X2_9TSVT A0 A1 B0 VDD VSS Y VNW VPW
MNM2 Y B0 VSS VPW nm1p2_svt_lp W=940e-9 L=60e-9 MR=1
MNM1 net19 A1 VSS VPW nm1p2_svt_lp W=940e-9 L=60e-9 MR=1
MNM0 Y A0 net19 VPW nm1p2_svt_lp W=940e-9 L=60e-9 MR=1
MPM2 net15 B0 VDD VNW pm1p2_svt_lp W=1.18e-6 L=60e-9 MR=1
MPM1 Y A1 net15 VNW pm1p2_svt_lp W=1.18e-6 L=60e-9 MR=1
MPM0 Y A0 net15 VNW pm1p2_svt_lp W=1.18e-6 L=60e-9 MR=1
.ENDS
.SUBCKT AOI21X4_9TSVT A0 A1 B0 VDD VSS Y VNW VPW
MM2 Y net014 VSS VPW nm1p2_svt_lp W=1.88u L=60n MR=1
MM0 net014 net010 VSS VPW nm1p2_svt_lp W=940n L=60n MR=1
MNM2 net010 B0 VSS VPW nm1p2_svt_lp W=470n L=60n MR=1
MNM1 net19 A1 VSS VPW nm1p2_svt_lp W=470n L=60n MR=1
MNM0 net010 A0 net19 VPW nm1p2_svt_lp W=470n L=60n MR=1
MM3 Y net014 VDD VNW pm1p2_svt_lp W=2.36u L=60n MR=1
MM1 net014 net010 VDD VNW pm1p2_svt_lp W=1.18u L=60n MR=1
MPM2 net15 B0 VDD VNW pm1p2_svt_lp W=590n L=60n MR=1
MPM1 net010 A1 net15 VNW pm1p2_svt_lp W=590n L=60n MR=1
MPM0 net010 A0 net15 VNW pm1p2_svt_lp W=590n L=60n MR=1
.ENDS
.SUBCKT AOI221X0P5_9TSVT A0 A1 B0 B1 C0 VDD VSS Y VNW VPW
MNM4 Y C0 VSS VPW nm1p2_svt_lp W=230e-9 L=60e-9 MR=1
MNM3 net28 B1 VSS VPW nm1p2_svt_lp W=230e-9 L=60e-9 MR=1
MNM2 Y B0 net28 VPW nm1p2_svt_lp W=230e-9 L=60e-9 MR=1
MNM1 net29 A1 VSS VPW nm1p2_svt_lp W=230e-9 L=60e-9 MR=1
MNM0 Y A0 net29 VPW nm1p2_svt_lp W=230e-9 L=60e-9 MR=1
MPM4 net20 C0 VDD VNW pm1p2_svt_lp W=300e-9 L=60e-9 MR=1
MPM3 net19 B1 net20 VNW pm1p2_svt_lp W=300e-9 L=60e-9 MR=1
MPM2 net19 B0 net20 VNW pm1p2_svt_lp W=300e-9 L=60e-9 MR=1
MPM1 Y A1 net19 VNW pm1p2_svt_lp W=300e-9 L=60e-9 MR=1
MPM0 Y A0 net19 VNW pm1p2_svt_lp W=300e-9 L=60e-9 MR=1
.ENDS
.SUBCKT AOI221X1_9TSVT A0 A1 B0 B1 C0 VDD VSS Y VNW VPW
MNM4 Y C0 VSS VPW nm1p2_svt_lp W=470e-9 L=60e-9 MR=1
MNM3 net28 B1 VSS VPW nm1p2_svt_lp W=470e-9 L=60e-9 MR=1
MNM2 Y B0 net28 VPW nm1p2_svt_lp W=470e-9 L=60e-9 MR=1
MNM1 net29 A1 VSS VPW nm1p2_svt_lp W=470e-9 L=60e-9 MR=1
MNM0 Y A0 net29 VPW nm1p2_svt_lp W=470e-9 L=60e-9 MR=1
MPM4 net20 C0 VDD VNW pm1p2_svt_lp W=590e-9 L=60e-9 MR=1
MPM3 net19 B1 net20 VNW pm1p2_svt_lp W=590e-9 L=60e-9 MR=1
MPM2 net19 B0 net20 VNW pm1p2_svt_lp W=590e-9 L=60e-9 MR=1
MPM1 Y A1 net19 VNW pm1p2_svt_lp W=590e-9 L=60e-9 MR=1
MPM0 Y A0 net19 VNW pm1p2_svt_lp W=590e-9 L=60e-9 MR=1
.ENDS
.SUBCKT AOI221X2_9TSVT A0 A1 B0 B1 C0 VDD VSS Y VNW VPW
MNM4 Y C0 VSS VPW nm1p2_svt_lp W=940e-9 L=60e-9 MR=1
MNM3 net28 B1 VSS VPW nm1p2_svt_lp W=940e-9 L=60e-9 MR=1
MNM2 Y B0 net28 VPW nm1p2_svt_lp W=940e-9 L=60e-9 MR=1
MNM1 net29 A1 VSS VPW nm1p2_svt_lp W=940e-9 L=60e-9 MR=1
MNM0 Y A0 net29 VPW nm1p2_svt_lp W=940e-9 L=60e-9 MR=1
MPM4 net20 C0 VDD VNW pm1p2_svt_lp W=1.18e-6 L=60e-9 MR=1
MPM3 net19 B1 net20 VNW pm1p2_svt_lp W=1.18e-6 L=60e-9 MR=1
MPM2 net19 B0 net20 VNW pm1p2_svt_lp W=1.18e-6 L=60e-9 MR=1
MPM1 Y A1 net19 VNW pm1p2_svt_lp W=1.18e-6 L=60e-9 MR=1
MPM0 Y A0 net19 VNW pm1p2_svt_lp W=1.18e-6 L=60e-9 MR=1
.ENDS
.SUBCKT AOI221X4_9TSVT A0 A1 B0 B1 C0 VDD VSS Y VNW VPW
MM3 Y net019 VSS VPW nm1p2_svt_lp W=1.88u L=60n MR=1
MM0 net019 net013 VSS VPW nm1p2_svt_lp W=940n L=60n MR=1
MNM4 net013 C0 VSS VPW nm1p2_svt_lp W=470n L=60n MR=1
MNM3 net28 B1 VSS VPW nm1p2_svt_lp W=470n L=60n MR=1
MNM2 net013 B0 net28 VPW nm1p2_svt_lp W=470n L=60n MR=1
MNM1 net29 A1 VSS VPW nm1p2_svt_lp W=470n L=60n MR=1
MNM0 net013 A0 net29 VPW nm1p2_svt_lp W=470n L=60n MR=1
MM2 Y net019 VDD VNW pm1p2_svt_lp W=2.36u L=60n MR=1
MM1 net019 net013 VDD VNW pm1p2_svt_lp W=1.18u L=60n MR=1
MPM4 net20 C0 VDD VNW pm1p2_svt_lp W=590n L=60n MR=1
MPM3 net19 B1 net20 VNW pm1p2_svt_lp W=590n L=60n MR=1
MPM2 net19 B0 net20 VNW pm1p2_svt_lp W=590n L=60n MR=1
MPM1 net013 A1 net19 VNW pm1p2_svt_lp W=590n L=60n MR=1
MPM0 net013 A0 net19 VNW pm1p2_svt_lp W=590n L=60n MR=1
.ENDS
.SUBCKT AOI222X0P5_9TSVT A0 A1 B0 B1 C0 C1 VDD VSS Y VNW VPW
MNM5 net31 C1 VSS VPW nm1p2_svt_lp W=230e-9 L=60e-9 MR=1
MNM4 Y C0 net31 VPW nm1p2_svt_lp W=230e-9 L=60e-9 MR=1
MNM3 net32 B1 VSS VPW nm1p2_svt_lp W=230e-9 L=60e-9 MR=1
MNM2 Y B0 net32 VPW nm1p2_svt_lp W=230e-9 L=60e-9 MR=1
MNM1 net33 A1 VSS VPW nm1p2_svt_lp W=230e-9 L=60e-9 MR=1
MNM0 Y A0 net33 VPW nm1p2_svt_lp W=230e-9 L=60e-9 MR=1
MPM5 net22 C1 VDD VNW pm1p2_svt_lp W=300e-9 L=60e-9 MR=1
MPM4 net22 C0 VDD VNW pm1p2_svt_lp W=300e-9 L=60e-9 MR=1
MPM3 net21 B1 net22 VNW pm1p2_svt_lp W=300e-9 L=60e-9 MR=1
MPM2 net21 B0 net22 VNW pm1p2_svt_lp W=300e-9 L=60e-9 MR=1
MPM1 Y A1 net21 VNW pm1p2_svt_lp W=300e-9 L=60e-9 MR=1
MPM0 Y A0 net21 VNW pm1p2_svt_lp W=300e-9 L=60e-9 MR=1
.ENDS
.SUBCKT AOI222X1_9TSVT A0 A1 B0 B1 C0 C1 VDD VSS Y VNW VPW
MNM5 net31 C1 VSS VPW nm1p2_svt_lp W=470e-9 L=60e-9 MR=1
MNM4 Y C0 net31 VPW nm1p2_svt_lp W=470e-9 L=60e-9 MR=1
MNM3 net32 B1 VSS VPW nm1p2_svt_lp W=470e-9 L=60e-9 MR=1
MNM2 Y B0 net32 VPW nm1p2_svt_lp W=470e-9 L=60e-9 MR=1
MNM1 net33 A1 VSS VPW nm1p2_svt_lp W=470e-9 L=60e-9 MR=1
MNM0 Y A0 net33 VPW nm1p2_svt_lp W=470e-9 L=60e-9 MR=1
MPM5 net22 C1 VDD VNW pm1p2_svt_lp W=590e-9 L=60e-9 MR=1
MPM4 net22 C0 VDD VNW pm1p2_svt_lp W=590e-9 L=60e-9 MR=1
MPM3 net21 B1 net22 VNW pm1p2_svt_lp W=590e-9 L=60e-9 MR=1
MPM2 net21 B0 net22 VNW pm1p2_svt_lp W=590e-9 L=60e-9 MR=1
MPM1 Y A1 net21 VNW pm1p2_svt_lp W=590e-9 L=60e-9 MR=1
MPM0 Y A0 net21 VNW pm1p2_svt_lp W=590e-9 L=60e-9 MR=1
.ENDS
.SUBCKT AOI222X2_9TSVT A0 A1 B0 B1 C0 C1 VDD VSS Y VNW VPW
MNM5 net31 C1 VSS VPW nm1p2_svt_lp W=940e-9 L=60e-9 MR=1
MNM4 Y C0 net31 VPW nm1p2_svt_lp W=940e-9 L=60e-9 MR=1
MNM3 net32 B1 VSS VPW nm1p2_svt_lp W=940e-9 L=60e-9 MR=1
MNM2 Y B0 net32 VPW nm1p2_svt_lp W=940e-9 L=60e-9 MR=1
MNM1 net33 A1 VSS VPW nm1p2_svt_lp W=940e-9 L=60e-9 MR=1
MNM0 Y A0 net33 VPW nm1p2_svt_lp W=940e-9 L=60e-9 MR=1
MPM5 net22 C1 VDD VNW pm1p2_svt_lp W=1.18e-6 L=60e-9 MR=1
MPM4 net22 C0 VDD VNW pm1p2_svt_lp W=1.18e-6 L=60e-9 MR=1
MPM3 net21 B1 net22 VNW pm1p2_svt_lp W=1.18e-6 L=60e-9 MR=1
MPM2 net21 B0 net22 VNW pm1p2_svt_lp W=1.18e-6 L=60e-9 MR=1
MPM1 Y A1 net21 VNW pm1p2_svt_lp W=1.18e-6 L=60e-9 MR=1
MPM0 Y A0 net21 VNW pm1p2_svt_lp W=1.18e-6 L=60e-9 MR=1
.ENDS
.SUBCKT AOI222X4_9TSVT A0 A1 B0 B1 C0 C1 VDD VSS Y VNW VPW
MM2 Y net021 VSS VPW nm1p2_svt_lp W=1.88u L=60n MR=1
MM0 net021 net014 VSS VPW nm1p2_svt_lp W=940n L=60n MR=1
MNM5 net31 C1 VSS VPW nm1p2_svt_lp W=470n L=60n MR=1
MNM4 net014 C0 net31 VPW nm1p2_svt_lp W=470n L=60n MR=1
MNM3 net32 B1 VSS VPW nm1p2_svt_lp W=470n L=60n MR=1
MNM2 net014 B0 net32 VPW nm1p2_svt_lp W=470n L=60n MR=1
MNM1 net33 A1 VSS VPW nm1p2_svt_lp W=470n L=60n MR=1
MNM0 net014 A0 net33 VPW nm1p2_svt_lp W=470n L=60n MR=1
MM3 Y net021 VDD VNW pm1p2_svt_lp W=2.36u L=60n MR=1
MM1 net021 net014 VDD VNW pm1p2_svt_lp W=1.18u L=60n MR=1
MPM5 net22 C1 VDD VNW pm1p2_svt_lp W=590n L=60n MR=1
MPM4 net22 C0 VDD VNW pm1p2_svt_lp W=590n L=60n MR=1
MPM3 net21 B1 net22 VNW pm1p2_svt_lp W=590n L=60n MR=1
MPM2 net21 B0 net22 VNW pm1p2_svt_lp W=590n L=60n MR=1
MPM1 net014 A1 net21 VNW pm1p2_svt_lp W=590n L=60n MR=1
MPM0 net014 A0 net21 VNW pm1p2_svt_lp W=590n L=60n MR=1
.ENDS
.SUBCKT AOI22BBX0P5_9TSVT AN0 AN1 B0 B1 VDD VSS Y VNW VPW
MPM4 net23 B1 VDD VNW pm1p2_svt_lp W=300e-9 L=60e-9 MR=1
MPM3 net23 B0 VDD VNW pm1p2_svt_lp W=300e-9 L=60e-9 MR=1
MPM2 Y net16 net23 VNW pm1p2_svt_lp W=300e-9 L=60e-9 MR=1
MPM1 net27 AN1 VDD VNW pm1p2_svt_lp W=300e-9 L=60e-9 MR=1
MPM0 net16 AN0 net27 VNW pm1p2_svt_lp W=300e-9 L=60e-9 MR=1
MNM4 net26 B1 VSS VPW nm1p2_svt_lp W=230e-9 L=60e-9 MR=1
MNM3 Y B0 net26 VPW nm1p2_svt_lp W=230e-9 L=60e-9 MR=1
MNM2 Y net16 VSS VPW nm1p2_svt_lp W=230e-9 L=60e-9 MR=1
MNM1 net16 AN1 VSS VPW nm1p2_svt_lp W=230e-9 L=60e-9 MR=1
MNM0 net16 AN0 VSS VPW nm1p2_svt_lp W=230e-9 L=60e-9 MR=1
.ENDS
.SUBCKT AOI22BBX1_9TSVT AN0 AN1 B0 B1 VDD VSS Y VNW VPW
MPM4 net23 B1 VDD VNW pm1p2_svt_lp W=590e-9 L=60e-9 MR=1
MPM3 net23 B0 VDD VNW pm1p2_svt_lp W=590e-9 L=60e-9 MR=1
MPM2 Y net16 net23 VNW pm1p2_svt_lp W=590e-9 L=60e-9 MR=1
MPM1 net27 AN1 VDD VNW pm1p2_svt_lp W=300n L=60n MR=1
MPM0 net16 AN0 net27 VNW pm1p2_svt_lp W=300n L=60n MR=1
MNM4 net26 B1 VSS VPW nm1p2_svt_lp W=470e-9 L=60e-9 MR=1
MNM3 Y B0 net26 VPW nm1p2_svt_lp W=470e-9 L=60e-9 MR=1
MNM2 Y net16 VSS VPW nm1p2_svt_lp W=470e-9 L=60e-9 MR=1
MNM1 net16 AN1 VSS VPW nm1p2_svt_lp W=230n L=60n MR=1
MNM0 net16 AN0 VSS VPW nm1p2_svt_lp W=230n L=60n MR=1
.ENDS
.SUBCKT AOI22BBX2_9TSVT AN0 AN1 B0 B1 VDD VSS Y VNW VPW
MPM4 net23 B1 VDD VNW pm1p2_svt_lp W=1.18e-6 L=60e-9 MR=1
MPM3 net23 B0 VDD VNW pm1p2_svt_lp W=1.18e-6 L=60e-9 MR=1
MPM2 Y net16 net23 VNW pm1p2_svt_lp W=1.18e-6 L=60e-9 MR=1
MPM1 net27 AN1 VDD VNW pm1p2_svt_lp W=590e-9 L=60e-9 MR=1
MPM0 net16 AN0 net27 VNW pm1p2_svt_lp W=590e-9 L=60e-9 MR=1
MNM4 net26 B1 VSS VPW nm1p2_svt_lp W=940e-9 L=60e-9 MR=1
MNM3 Y B0 net26 VPW nm1p2_svt_lp W=940e-9 L=60e-9 MR=1
MNM2 Y net16 VSS VPW nm1p2_svt_lp W=940e-9 L=60e-9 MR=1
MNM1 net16 AN1 VSS VPW nm1p2_svt_lp W=470e-9 L=60e-9 MR=1
MNM0 net16 AN0 VSS VPW nm1p2_svt_lp W=470e-9 L=60e-9 MR=1
.ENDS
.SUBCKT AOI22BBX4_9TSVT AN0 AN1 B0 B1 VDD VSS Y VNW VPW
MM2 Y net019 VDD VNW pm1p2_svt_lp W=2.36u L=60n MR=1
MM1 net019 net015 VDD VNW pm1p2_svt_lp W=1.18u L=60n MR=1
MPM4 net23 B1 VDD VNW pm1p2_svt_lp W=590n L=60n MR=1
MPM3 net23 B0 VDD VNW pm1p2_svt_lp W=590n L=60n MR=1
MPM2 net015 net16 net23 VNW pm1p2_svt_lp W=590n L=60n MR=1
MPM1 net27 AN1 VDD VNW pm1p2_svt_lp W=300n L=60n MR=1
MPM0 net16 AN0 net27 VNW pm1p2_svt_lp W=300n L=60n MR=1
MM3 Y net019 VSS VPW nm1p2_svt_lp W=1.88u L=60n MR=1
MM0 net019 net015 VSS VPW nm1p2_svt_lp W=940n L=60n MR=1
MNM4 net26 B1 VSS VPW nm1p2_svt_lp W=470n L=60n MR=1
MNM3 net015 B0 net26 VPW nm1p2_svt_lp W=470n L=60n MR=1
MNM2 net015 net16 VSS VPW nm1p2_svt_lp W=470n L=60n MR=1
MNM1 net16 AN1 VSS VPW nm1p2_svt_lp W=230n L=60n MR=1
MNM0 net16 AN0 VSS VPW nm1p2_svt_lp W=230n L=60n MR=1
.ENDS
.SUBCKT AOI22X0P5_9TSVT A0 A1 B0 B1 VDD VSS Y VNW VPW
MNM3 net23 B1 VSS VPW nm1p2_svt_lp W=230e-9 L=60e-9 MR=1
MNM2 Y B0 net23 VPW nm1p2_svt_lp W=230e-9 L=60e-9 MR=1
MNM1 net24 A1 VSS VPW nm1p2_svt_lp W=230e-9 L=60e-9 MR=1
MNM0 Y A0 net24 VPW nm1p2_svt_lp W=230e-9 L=60e-9 MR=1
MPM3 net17 B1 VDD VNW pm1p2_svt_lp W=300e-9 L=60e-9 MR=1
MPM2 net17 B0 VDD VNW pm1p2_svt_lp W=300e-9 L=60e-9 MR=1
MPM1 Y A1 net17 VNW pm1p2_svt_lp W=300e-9 L=60e-9 MR=1
MPM0 Y A0 net17 VNW pm1p2_svt_lp W=300e-9 L=60e-9 MR=1
.ENDS
.SUBCKT AOI22X1_9TSVT A0 A1 B0 B1 VDD VSS Y VNW VPW
MNM3 net23 B1 VSS VPW nm1p2_svt_lp W=470e-9 L=60e-9 MR=1
MNM2 Y B0 net23 VPW nm1p2_svt_lp W=470e-9 L=60e-9 MR=1
MNM1 net24 A1 VSS VPW nm1p2_svt_lp W=470e-9 L=60e-9 MR=1
MNM0 Y A0 net24 VPW nm1p2_svt_lp W=470e-9 L=60e-9 MR=1
MPM3 net17 B1 VDD VNW pm1p2_svt_lp W=590e-9 L=60e-9 MR=1
MPM2 net17 B0 VDD VNW pm1p2_svt_lp W=590e-9 L=60e-9 MR=1
MPM1 Y A1 net17 VNW pm1p2_svt_lp W=590e-9 L=60e-9 MR=1
MPM0 Y A0 net17 VNW pm1p2_svt_lp W=590e-9 L=60e-9 MR=1
.ENDS
.SUBCKT AOI22X2_9TSVT A0 A1 B0 B1 VDD VSS Y VNW VPW
MNM3 net23 B1 VSS VPW nm1p2_svt_lp W=940e-9 L=60e-9 MR=1
MNM2 Y B0 net23 VPW nm1p2_svt_lp W=940e-9 L=60e-9 MR=1
MNM1 net24 A1 VSS VPW nm1p2_svt_lp W=940e-9 L=60e-9 MR=1
MNM0 Y A0 net24 VPW nm1p2_svt_lp W=940e-9 L=60e-9 MR=1
MPM3 net17 B1 VDD VNW pm1p2_svt_lp W=1.18e-6 L=60e-9 MR=1
MPM2 net17 B0 VDD VNW pm1p2_svt_lp W=1.18e-6 L=60e-9 MR=1
MPM1 Y A1 net17 VNW pm1p2_svt_lp W=1.18e-6 L=60e-9 MR=1
MPM0 Y A0 net17 VNW pm1p2_svt_lp W=1.18e-6 L=60e-9 MR=1
.ENDS
.SUBCKT AOI22X4_9TSVT A0 A1 B0 B1 VDD VSS Y VNW VPW
MM3 Y net016 VSS VPW nm1p2_svt_lp W=1.88u L=60n MR=1
MM0 net016 net011 VSS VPW nm1p2_svt_lp W=940n L=60n MR=1
MNM3 net23 B1 VSS VPW nm1p2_svt_lp W=470n L=60n MR=1
MNM2 net011 B0 net23 VPW nm1p2_svt_lp W=470n L=60n MR=1
MNM1 net24 A1 VSS VPW nm1p2_svt_lp W=470n L=60n MR=1
MNM0 net011 A0 net24 VPW nm1p2_svt_lp W=470n L=60n MR=1
MM2 Y net016 VDD VNW pm1p2_svt_lp W=2.36u L=60n MR=1
MM1 net016 net011 VDD VNW pm1p2_svt_lp W=1.18u L=60n MR=1
MPM3 net17 B1 VDD VNW pm1p2_svt_lp W=590n L=60n MR=1
MPM2 net17 B0 VDD VNW pm1p2_svt_lp W=590n L=60n MR=1
MPM1 net011 A1 net17 VNW pm1p2_svt_lp W=590n L=60n MR=1
MPM0 net011 A0 net17 VNW pm1p2_svt_lp W=590n L=60n MR=1
.ENDS
.SUBCKT AOI31X0P5_9TSVT A0 A1 A2 B0 VDD VSS Y VNW VPW
MNM3 Y B0 VSS VPW nm1p2_svt_lp W=230e-9 L=60e-9 MR=1
MNM2 net23 A2 VSS VPW nm1p2_svt_lp W=230e-9 L=60e-9 MR=1
MNM1 net24 A1 net23 VPW nm1p2_svt_lp W=230e-9 L=60e-9 MR=1
MNM0 Y A0 net24 VPW nm1p2_svt_lp W=230e-9 L=60e-9 MR=1
MPM3 net21 B0 VDD VNW pm1p2_svt_lp W=300e-9 L=60e-9 MR=1
MPM2 Y A2 net21 VNW pm1p2_svt_lp W=300e-9 L=60e-9 MR=1
MPM1 Y A1 net21 VNW pm1p2_svt_lp W=300e-9 L=60e-9 MR=1
MPM0 Y A0 net21 VNW pm1p2_svt_lp W=300e-9 L=60e-9 MR=1
.ENDS
.SUBCKT AOI31X1_9TSVT A0 A1 A2 B0 VDD VSS Y VNW VPW
MNM3 Y B0 VSS VPW nm1p2_svt_lp W=470e-9 L=60e-9 MR=1
MNM2 net23 A2 VSS VPW nm1p2_svt_lp W=470e-9 L=60e-9 MR=1
MNM1 net24 A1 net23 VPW nm1p2_svt_lp W=470e-9 L=60e-9 MR=1
MNM0 Y A0 net24 VPW nm1p2_svt_lp W=470e-9 L=60e-9 MR=1
MPM3 net21 B0 VDD VNW pm1p2_svt_lp W=590e-9 L=60e-9 MR=1
MPM2 Y A2 net21 VNW pm1p2_svt_lp W=590e-9 L=60e-9 MR=1
MPM1 Y A1 net21 VNW pm1p2_svt_lp W=590e-9 L=60e-9 MR=1
MPM0 Y A0 net21 VNW pm1p2_svt_lp W=590e-9 L=60e-9 MR=1
.ENDS
.SUBCKT AOI31X2_9TSVT A0 A1 A2 B0 VDD VSS Y VNW VPW
MNM3 Y B0 VSS VPW nm1p2_svt_lp W=940e-9 L=60e-9 MR=1
MNM2 net23 A2 VSS VPW nm1p2_svt_lp W=940e-9 L=60e-9 MR=1
MNM1 net24 A1 net23 VPW nm1p2_svt_lp W=940e-9 L=60e-9 MR=1
MNM0 Y A0 net24 VPW nm1p2_svt_lp W=940e-9 L=60e-9 MR=1
MPM3 net21 B0 VDD VNW pm1p2_svt_lp W=1.18e-6 L=60e-9 MR=1
MPM2 Y A2 net21 VNW pm1p2_svt_lp W=1.18e-6 L=60e-9 MR=1
MPM1 Y A1 net21 VNW pm1p2_svt_lp W=1.18e-6 L=60e-9 MR=1
MPM0 Y A0 net21 VNW pm1p2_svt_lp W=1.18e-6 L=60e-9 MR=1
.ENDS
.SUBCKT AOI31X4_9TSVT A0 A1 A2 B0 VDD VSS Y VNW VPW
MM3 Y net017 VSS VPW nm1p2_svt_lp W=1.88u L=60n MR=1
MM0 net017 net012 VSS VPW nm1p2_svt_lp W=470e-9 L=60e-9 MR=1
MNM3 net012 B0 VSS VPW nm1p2_svt_lp W=470n L=60n MR=1
MNM2 net23 A2 VSS VPW nm1p2_svt_lp W=470n L=60n MR=1
MNM1 net24 A1 net23 VPW nm1p2_svt_lp W=470n L=60n MR=1
MNM0 net012 A0 net24 VPW nm1p2_svt_lp W=470n L=60n MR=1
MM2 Y net017 VDD VNW pm1p2_svt_lp W=2.36u L=60n MR=1
MM1 net017 net012 VDD VNW pm1p2_svt_lp W=590e-9 L=60e-9 MR=1
MPM3 net21 B0 VDD VNW pm1p2_svt_lp W=590n L=60n MR=1
MPM2 net012 A2 net21 VNW pm1p2_svt_lp W=590n L=60n MR=1
MPM1 net012 A1 net21 VNW pm1p2_svt_lp W=590n L=60n MR=1
MPM0 net012 A0 net21 VNW pm1p2_svt_lp W=590n L=60n MR=1
.ENDS
.SUBCKT AOI32X0P5_9TSVT A0 A1 A2 B0 B1 VDD VSS Y VNW VPW
MNM4 net27 B1 VSS VPW nm1p2_svt_lp W=230e-9 L=60e-9 MR=1
MNM3 Y B0 net27 VPW nm1p2_svt_lp W=230e-9 L=60e-9 MR=1
MNM2 net28 A2 VSS VPW nm1p2_svt_lp W=230e-9 L=60e-9 MR=1
MNM1 net29 A1 net28 VPW nm1p2_svt_lp W=230e-9 L=60e-9 MR=1
MNM0 Y A0 net29 VPW nm1p2_svt_lp W=230e-9 L=60e-9 MR=1
MPM4 net19 B1 VDD VNW pm1p2_svt_lp W=300e-9 L=60e-9 MR=1
MPM3 net19 B0 VDD VNW pm1p2_svt_lp W=300e-9 L=60e-9 MR=1
MPM2 Y A2 net19 VNW pm1p2_svt_lp W=300e-9 L=60e-9 MR=1
MPM1 Y A1 net19 VNW pm1p2_svt_lp W=300e-9 L=60e-9 MR=1
MPM0 Y A0 net19 VNW pm1p2_svt_lp W=300e-9 L=60e-9 MR=1
.ENDS
.SUBCKT AOI32X1_9TSVT A0 A1 A2 B0 B1 VDD VSS Y VNW VPW
MNM4 net27 B1 VSS VPW nm1p2_svt_lp W=470e-9 L=60e-9 MR=1
MNM3 Y B0 net27 VPW nm1p2_svt_lp W=470e-9 L=60e-9 MR=1
MNM2 net28 A2 VSS VPW nm1p2_svt_lp W=470e-9 L=60e-9 MR=1
MNM1 net29 A1 net28 VPW nm1p2_svt_lp W=470e-9 L=60e-9 MR=1
MNM0 Y A0 net29 VPW nm1p2_svt_lp W=470e-9 L=60e-9 MR=1
MPM4 net19 B1 VDD VNW pm1p2_svt_lp W=590e-9 L=60e-9 MR=1
MPM3 net19 B0 VDD VNW pm1p2_svt_lp W=590e-9 L=60e-9 MR=1
MPM2 Y A2 net19 VNW pm1p2_svt_lp W=590e-9 L=60e-9 MR=1
MPM1 Y A1 net19 VNW pm1p2_svt_lp W=590e-9 L=60e-9 MR=1
MPM0 Y A0 net19 VNW pm1p2_svt_lp W=590e-9 L=60e-9 MR=1
.ENDS
.SUBCKT AOI32X2_9TSVT A0 A1 A2 B0 B1 VDD VSS Y VNW VPW
MNM4 net27 B1 VSS VPW nm1p2_svt_lp W=940e-9 L=60e-9 MR=1
MNM3 Y B0 net27 VPW nm1p2_svt_lp W=940e-9 L=60e-9 MR=1
MNM2 net28 A2 VSS VPW nm1p2_svt_lp W=940e-9 L=60e-9 MR=1
MNM1 net29 A1 net28 VPW nm1p2_svt_lp W=940e-9 L=60e-9 MR=1
MNM0 Y A0 net29 VPW nm1p2_svt_lp W=940e-9 L=60e-9 MR=1
MPM4 net19 B1 VDD VNW pm1p2_svt_lp W=1.18e-6 L=60e-9 MR=1
MPM3 net19 B0 VDD VNW pm1p2_svt_lp W=1.18e-6 L=60e-9 MR=1
MPM2 Y A2 net19 VNW pm1p2_svt_lp W=1.18e-6 L=60e-9 MR=1
MPM1 Y A1 net19 VNW pm1p2_svt_lp W=1.18e-6 L=60e-9 MR=1
MPM0 Y A0 net19 VNW pm1p2_svt_lp W=1.18e-6 L=60e-9 MR=1
.ENDS
.SUBCKT AOI32X4_9TSVT A0 A1 A2 B0 B1 VDD VSS Y VNW VPW
MM3 Y net018 VSS VPW nm1p2_svt_lp W=1.88u L=60n MR=1
MM0 net018 net013 VSS VPW nm1p2_svt_lp W=940n L=60n MR=1
MNM4 net27 B1 VSS VPW nm1p2_svt_lp W=470n L=60n MR=1
MNM3 net013 B0 net27 VPW nm1p2_svt_lp W=470n L=60n MR=1
MNM2 net28 A2 VSS VPW nm1p2_svt_lp W=470n L=60n MR=1
MNM1 net29 A1 net28 VPW nm1p2_svt_lp W=470n L=60n MR=1
MNM0 net013 A0 net29 VPW nm1p2_svt_lp W=470n L=60n MR=1
MM2 Y net018 VDD VNW pm1p2_svt_lp W=2.36u L=60n MR=1
MM1 net018 net013 VDD VNW pm1p2_svt_lp W=1.18u L=60n MR=1
MPM4 net19 B1 VDD VNW pm1p2_svt_lp W=590n L=60n MR=1
MPM3 net19 B0 VDD VNW pm1p2_svt_lp W=590n L=60n MR=1
MPM2 net013 A2 net19 VNW pm1p2_svt_lp W=590n L=60n MR=1
MPM1 net013 A1 net19 VNW pm1p2_svt_lp W=590n L=60n MR=1
MPM0 net013 A0 net19 VNW pm1p2_svt_lp W=590n L=60n MR=1
.ENDS
.SUBCKT AOI33X0P5_9TSVT A0 A1 A2 B0 B1 B2 VDD VSS Y VNW VPW
MNM5 net31 B2 VSS VPW nm1p2_svt_lp W=230e-9 L=60e-9 MR=1
MNM4 net32 B1 net31 VPW nm1p2_svt_lp W=230e-9 L=60e-9 MR=1
MNM3 Y B0 net32 VPW nm1p2_svt_lp W=230e-9 L=60e-9 MR=1
MNM2 net33 A2 VSS VPW nm1p2_svt_lp W=230e-9 L=60e-9 MR=1
MNM1 net34 A1 net33 VPW nm1p2_svt_lp W=230e-9 L=60e-9 MR=1
MNM0 Y A0 net34 VPW nm1p2_svt_lp W=230e-9 L=60e-9 MR=1
MPM5 net21 B2 VDD VNW pm1p2_svt_lp W=300e-9 L=60e-9 MR=1
MPM4 net21 B1 VDD VNW pm1p2_svt_lp W=300e-9 L=60e-9 MR=1
MPM3 net21 B0 VDD VNW pm1p2_svt_lp W=300e-9 L=60e-9 MR=1
MPM2 Y A2 net21 VNW pm1p2_svt_lp W=300e-9 L=60e-9 MR=1
MPM1 Y A1 net21 VNW pm1p2_svt_lp W=300e-9 L=60e-9 MR=1
MPM0 Y A0 net21 VNW pm1p2_svt_lp W=300e-9 L=60e-9 MR=1
.ENDS
.SUBCKT AOI33X1_9TSVT A0 A1 A2 B0 B1 B2 VDD VSS Y VNW VPW
MNM5 net31 B2 VSS VPW nm1p2_svt_lp W=470e-9 L=60e-9 MR=1
MNM4 net32 B1 net31 VPW nm1p2_svt_lp W=470e-9 L=60e-9 MR=1
MNM3 Y B0 net32 VPW nm1p2_svt_lp W=470e-9 L=60e-9 MR=1
MNM2 net33 A2 VSS VPW nm1p2_svt_lp W=470e-9 L=60e-9 MR=1
MNM1 net34 A1 net33 VPW nm1p2_svt_lp W=470e-9 L=60e-9 MR=1
MNM0 Y A0 net34 VPW nm1p2_svt_lp W=470e-9 L=60e-9 MR=1
MPM5 net21 B2 VDD VNW pm1p2_svt_lp W=590e-9 L=60e-9 MR=1
MPM4 net21 B1 VDD VNW pm1p2_svt_lp W=590e-9 L=60e-9 MR=1
MPM3 net21 B0 VDD VNW pm1p2_svt_lp W=590e-9 L=60e-9 MR=1
MPM2 Y A2 net21 VNW pm1p2_svt_lp W=590e-9 L=60e-9 MR=1
MPM1 Y A1 net21 VNW pm1p2_svt_lp W=590e-9 L=60e-9 MR=1
MPM0 Y A0 net21 VNW pm1p2_svt_lp W=590e-9 L=60e-9 MR=1
.ENDS
.SUBCKT AOI33X2_9TSVT A0 A1 A2 B0 B1 B2 VDD VSS Y VNW VPW
MNM5 net31 B2 VSS VPW nm1p2_svt_lp W=940e-9 L=60e-9 MR=1
MNM4 net32 B1 net31 VPW nm1p2_svt_lp W=940e-9 L=60e-9 MR=1
MNM3 Y B0 net32 VPW nm1p2_svt_lp W=940e-9 L=60e-9 MR=1
MNM2 net33 A2 VSS VPW nm1p2_svt_lp W=940e-9 L=60e-9 MR=1
MNM1 net34 A1 net33 VPW nm1p2_svt_lp W=940e-9 L=60e-9 MR=1
MNM0 Y A0 net34 VPW nm1p2_svt_lp W=940e-9 L=60e-9 MR=1
MPM5 net21 B2 VDD VNW pm1p2_svt_lp W=1.18e-6 L=60e-9 MR=1
MPM4 net21 B1 VDD VNW pm1p2_svt_lp W=1.18e-6 L=60e-9 MR=1
MPM3 net21 B0 VDD VNW pm1p2_svt_lp W=1.18e-6 L=60e-9 MR=1
MPM2 Y A2 net21 VNW pm1p2_svt_lp W=1.18e-6 L=60e-9 MR=1
MPM1 Y A1 net21 VNW pm1p2_svt_lp W=1.18e-6 L=60e-9 MR=1
MPM0 Y A0 net21 VNW pm1p2_svt_lp W=1.18e-6 L=60e-9 MR=1
.ENDS
.SUBCKT AOI33X4_9TSVT A0 A1 A2 B0 B1 B2 VDD VSS Y VNW VPW
MM3 Y net021 VSS VPW nm1p2_svt_lp W=1.88u L=60n MR=1
MM0 net021 net014 VSS VPW nm1p2_svt_lp W=940n L=60n MR=1
MNM5 net31 B2 VSS VPW nm1p2_svt_lp W=470n L=60n MR=1
MNM4 net32 B1 net31 VPW nm1p2_svt_lp W=470n L=60n MR=1
MNM3 net014 B0 net32 VPW nm1p2_svt_lp W=470n L=60n MR=1
MNM2 net33 A2 VSS VPW nm1p2_svt_lp W=470n L=60n MR=1
MNM1 net34 A1 net33 VPW nm1p2_svt_lp W=470n L=60n MR=1
MNM0 net014 A0 net34 VPW nm1p2_svt_lp W=470n L=60n MR=1
MM2 Y net021 VDD VNW pm1p2_svt_lp W=2.36u L=60n MR=1
MM1 net021 net014 VDD VNW pm1p2_svt_lp W=1.18u L=60n MR=1
MPM5 net21 B2 VDD VNW pm1p2_svt_lp W=590n L=60n MR=1
MPM4 net21 B1 VDD VNW pm1p2_svt_lp W=590n L=60n MR=1
MPM3 net21 B0 VDD VNW pm1p2_svt_lp W=590n L=60n MR=1
MPM2 net014 A2 net21 VNW pm1p2_svt_lp W=590n L=60n MR=1
MPM1 net014 A1 net21 VNW pm1p2_svt_lp W=590n L=60n MR=1
MPM0 net014 A0 net21 VNW pm1p2_svt_lp W=590n L=60n MR=1
.ENDS
.SUBCKT BENCX0P5_9TSVT A M0 M1 M2 S VDD VSS X2 VNW VPW
MPM15 S M2 VDD VNW pm1p2_svt_lp W=300n L=60n MR=1
MPM14 net50 M1N VDD VNW pm1p2_svt_lp W=300n L=60n MR=1
MPM13 S M0N net50 VNW pm1p2_svt_lp W=300n L=60n MR=1
MPM12 A M2N VDD VNW pm1p2_svt_lp W=300n L=60n MR=1
MPM11 net51 M1 VDD VNW pm1p2_svt_lp W=300n L=60n MR=1
MPM10 A M0 net51 VNW pm1p2_svt_lp W=300n L=60n MR=1
MPM9 M2N M2 VDD VNW pm1p2_svt_lp W=300n L=60n MR=1
MPM5 X2 net31 VDD VNW pm1p2_svt_lp W=300n L=60n MR=1
MPM4 net31 M1 net53 VNW pm1p2_svt_lp W=300n L=60n MR=1
MPM3 net53 M0N VDD VNW pm1p2_svt_lp W=300n L=60n MR=1
MPM2 net31 M1N M0N VNW pm1p2_svt_lp W=300n L=60n MR=1
MPM1 M1N M1 VDD VNW pm1p2_svt_lp W=300n L=60n MR=1
MPM0 M0N M0 VDD VNW pm1p2_svt_lp W=300n L=60n MR=1
MNM15 net40 M2 VSS VPW nm1p2_svt_lp W=230n L=60n MR=1
MNM14 S M1N net40 VPW nm1p2_svt_lp W=230n L=60n MR=1
MNM13 S M0N net40 VPW nm1p2_svt_lp W=230n L=60n MR=1
MNM12 net28 M2N VSS VPW nm1p2_svt_lp W=230n L=60n MR=1
MNM11 A M1 net28 VPW nm1p2_svt_lp W=230n L=60n MR=1
MNM10 A M0 net28 VPW nm1p2_svt_lp W=230n L=60n MR=1
MNM9 M2N M2 VSS VPW nm1p2_svt_lp W=230n L=60n MR=1
MNM5 X2 net31 VSS VPW nm1p2_svt_lp W=230n L=60n MR=1
MNM3 net52 M0N VSS VPW nm1p2_svt_lp W=230n L=60n MR=1
MNM4 net31 M1N net52 VPW nm1p2_svt_lp W=230n L=60n MR=1
MNM2 net31 M1 M0N VPW nm1p2_svt_lp W=230n L=60n MR=1
MNM1 M1N M1 VSS VPW nm1p2_svt_lp W=230n L=60n MR=1
MNM0 M0N M0 VSS VPW nm1p2_svt_lp W=230n L=60n MR=1
.ENDS
.SUBCKT BENCX1_9TSVT A M0 M1 M2 S VDD VSS X2 VNW VPW
MPM15 S M2 VDD VNW pm1p2_svt_lp W=590n L=60n MR=1
MPM14 net50 M1N VDD VNW pm1p2_svt_lp W=590n L=60n MR=1
MPM13 S M0N net50 VNW pm1p2_svt_lp W=590n L=60n MR=1
MPM12 A M2N VDD VNW pm1p2_svt_lp W=590n L=60n MR=1
MPM11 net51 M1 VDD VNW pm1p2_svt_lp W=590n L=60n MR=1
MPM10 A M0 net51 VNW pm1p2_svt_lp W=590n L=60n MR=1
MPM9 M2N M2 VDD VNW pm1p2_svt_lp W=590n L=60n MR=1
MPM5 X2 net31 VDD VNW pm1p2_svt_lp W=590n L=60n MR=1
MPM4 net31 M1 net53 VNW pm1p2_svt_lp W=590n L=60n MR=1
MPM3 net53 M0N VDD VNW pm1p2_svt_lp W=590n L=60n MR=1
MPM2 net31 M1N M0N VNW pm1p2_svt_lp W=590n L=60n MR=1
MPM1 M1N M1 VDD VNW pm1p2_svt_lp W=590n L=60n MR=1
MPM0 M0N M0 VDD VNW pm1p2_svt_lp W=590n L=60n MR=1
MNM15 net40 M2 VSS VPW nm1p2_svt_lp W=470n L=60n MR=1
MNM14 S M1N net40 VPW nm1p2_svt_lp W=470n L=60n MR=1
MNM13 S M0N net40 VPW nm1p2_svt_lp W=470n L=60n MR=1
MNM12 net28 M2N VSS VPW nm1p2_svt_lp W=470n L=60n MR=1
MNM11 A M1 net28 VPW nm1p2_svt_lp W=470n L=60n MR=1
MNM10 A M0 net28 VPW nm1p2_svt_lp W=470n L=60n MR=1
MNM9 M2N M2 VSS VPW nm1p2_svt_lp W=470n L=60n MR=1
MNM5 X2 net31 VSS VPW nm1p2_svt_lp W=470n L=60n MR=1
MNM3 net52 M0N VSS VPW nm1p2_svt_lp W=470n L=60n MR=1
MNM4 net31 M1N net52 VPW nm1p2_svt_lp W=470n L=60n MR=1
MNM2 net31 M1 M0N VPW nm1p2_svt_lp W=470n L=60n MR=1
MNM1 M1N M1 VSS VPW nm1p2_svt_lp W=470n L=60n MR=1
MNM0 M0N M0 VSS VPW nm1p2_svt_lp W=470n L=60n MR=1
.ENDS
.SUBCKT BENCX2_9TSVT A M0 M1 M2 S VDD VSS X2 VNW VPW
MPM15 S M2 VDD VNW pm1p2_svt_lp W=1.18u L=60n MR=1
MPM14 net50 M1N VDD VNW pm1p2_svt_lp W=1.18u L=60n MR=1
MPM13 S M0N net50 VNW pm1p2_svt_lp W=1.18u L=60n MR=1
MPM12 A M2N VDD VNW pm1p2_svt_lp W=1.18u L=60n MR=1
MPM11 net51 M1 VDD VNW pm1p2_svt_lp W=1.18u L=60n MR=1
MPM10 A M0 net51 VNW pm1p2_svt_lp W=1.18u L=60n MR=1
MPM9 M2N M2 VDD VNW pm1p2_svt_lp W=590n L=60n MR=1
MPM5 X2 net31 VDD VNW pm1p2_svt_lp W=1.18u L=60n MR=1
MPM4 net31 M1 net53 VNW pm1p2_svt_lp W=590n L=60n MR=1
MPM3 net53 M0N VDD VNW pm1p2_svt_lp W=590n L=60n MR=1
MPM2 net31 M1N M0N VNW pm1p2_svt_lp W=590n L=60n MR=1
MPM1 M1N M1 VDD VNW pm1p2_svt_lp W=590n L=60n MR=1
MPM0 M0N M0 VDD VNW pm1p2_svt_lp W=590n L=60n MR=1
MNM15 net40 M2 VSS VPW nm1p2_svt_lp W=940n L=60n MR=1
MNM14 S M1N net40 VPW nm1p2_svt_lp W=940n L=60n MR=1
MNM13 S M0N net40 VPW nm1p2_svt_lp W=940n L=60n MR=1
MNM12 net28 M2N VSS VPW nm1p2_svt_lp W=940n L=60n MR=1
MNM11 A M1 net28 VPW nm1p2_svt_lp W=940n L=60n MR=1
MNM10 A M0 net28 VPW nm1p2_svt_lp W=940n L=60n MR=1
MNM9 M2N M2 VSS VPW nm1p2_svt_lp W=470n L=60n MR=1
MNM5 X2 net31 VSS VPW nm1p2_svt_lp W=940n L=60n MR=1
MNM3 net52 M0N VSS VPW nm1p2_svt_lp W=470n L=60n MR=1
MNM4 net31 M1N net52 VPW nm1p2_svt_lp W=470n L=60n MR=1
MNM2 net31 M1 M0N VPW nm1p2_svt_lp W=470n L=60n MR=1
MNM1 M1N M1 VSS VPW nm1p2_svt_lp W=470n L=60n MR=1
MNM0 M0N M0 VSS VPW nm1p2_svt_lp W=470n L=60n MR=1
.ENDS
.SUBCKT BENCX4_9TSVT A M0 M1 M2 S VDD VSS X2 VNW VPW
MM10 net025 net048 VDD VNW pm1p2_svt_lp W=1.18u L=60n MR=1
MM9 A net025 VDD VNW pm1p2_svt_lp W=2.36u L=60n MR=1
MM6 net044 net052 VDD VNW pm1p2_svt_lp W=1.18u L=60n MR=1
MM5 S net044 VDD VNW pm1p2_svt_lp W=2.36u L=60n MR=1
MPM15 net052 M2 VDD VNW pm1p2_svt_lp W=590n L=60n MR=1
MPM14 net50 M1N VDD VNW pm1p2_svt_lp W=590n L=60n MR=1
MPM13 net052 M0N net50 VNW pm1p2_svt_lp W=590n L=60n MR=1
MPM12 net048 M2N VDD VNW pm1p2_svt_lp W=590n L=60n MR=1
MPM11 net51 M1 VDD VNW pm1p2_svt_lp W=590n L=60n MR=1
MPM10 net048 M0 net51 VNW pm1p2_svt_lp W=590n L=60n MR=1
MPM9 M2N M2 VDD VNW pm1p2_svt_lp W=590n L=60n MR=1
MPM5 X2 net31 VDD VNW pm1p2_svt_lp W=2.36u L=60n MR=1
MPM4 net31 M1 net53 VNW pm1p2_svt_lp W=590n L=60n MR=1
MPM3 net53 M0N VDD VNW pm1p2_svt_lp W=590n L=60n MR=1
MPM2 net31 M1N M0N VNW pm1p2_svt_lp W=590n L=60n MR=1
MPM1 M1N M1 VDD VNW pm1p2_svt_lp W=590n L=60n MR=1
MPM0 M0N M0 VDD VNW pm1p2_svt_lp W=590n L=60n MR=1
MM11 net025 net048 VSS VPW nm1p2_svt_lp W=940n L=60n MR=1
MM8 A net025 VSS VPW nm1p2_svt_lp W=1.88u L=60n MR=1
MM7 net044 net052 VSS VPW nm1p2_svt_lp W=940n L=60n MR=1
MM4 S net044 VSS VPW nm1p2_svt_lp W=1.88u L=60n MR=1
MNM15 net40 M2 VSS VPW nm1p2_svt_lp W=470n L=60n MR=1
MNM14 net052 M1N net40 VPW nm1p2_svt_lp W=470n L=60n MR=1
MNM13 net052 M0N net40 VPW nm1p2_svt_lp W=470n L=60n MR=1
MNM12 net28 M2N VSS VPW nm1p2_svt_lp W=470n L=60n MR=1
MNM11 net048 M1 net28 VPW nm1p2_svt_lp W=470n L=60n MR=1
MNM10 net048 M0 net28 VPW nm1p2_svt_lp W=470n L=60n MR=1
MNM9 M2N M2 VSS VPW nm1p2_svt_lp W=470n L=60n MR=1
MNM5 X2 net31 VSS VPW nm1p2_svt_lp W=1.88u L=60n MR=1
MNM3 net52 M0N VSS VPW nm1p2_svt_lp W=470n L=60n MR=1
MNM4 net31 M1N net52 VPW nm1p2_svt_lp W=470n L=60n MR=1
MNM2 net31 M1 M0N VPW nm1p2_svt_lp W=470n L=60n MR=1
MNM1 M1N M1 VSS VPW nm1p2_svt_lp W=470n L=60n MR=1
MNM0 M0N M0 VSS VPW nm1p2_svt_lp W=470n L=60n MR=1
.ENDS
.SUBCKT BHDX1_9TSVT VDD VSS Y VNW VPW
MNM1 Y net10 VSS VPW nm1p2_svt_lp W=230e-9 L=60e-9 MR=1
MNM0 net10 Y VSS VPW nm1p2_svt_lp W=470e-9 L=60e-9 MR=1
MPM1 Y net10 VDD VNW pm1p2_svt_lp W=300e-9 L=60e-9 MR=1
MPM0 net10 Y VDD VNW pm1p2_svt_lp W=590e-9 L=60e-9 MR=1
.ENDS
.SUBCKT BUFX0P5_9TSVT A VDD VSS Y VNW VPW
MNM1 Y net11 VSS VPW nm1p2_svt_lp W=230e-9 L=60e-9 MR=1
MNM0 net11 A VSS VPW nm1p2_svt_lp W=230e-9 L=60e-9 MR=1
MPM1 Y net11 VDD VNW pm1p2_svt_lp W=300e-9 L=60e-9 MR=1
MPM0 net11 A VDD VNW pm1p2_svt_lp W=300e-9 L=60e-9 MR=1
.ENDS
.SUBCKT BUFX10_9TSVT A VDD VSS Y VNW VPW
MNM1 Y net11 VSS VPW nm1p2_svt_lp W=4.7e-6 L=60e-9 MR=1
MNM0 net11 A VSS VPW nm1p2_svt_lp W=1.88e-6 L=60e-9 MR=1
MPM1 Y net11 VDD VNW pm1p2_svt_lp W=5.9e-6 L=60e-9 MR=1
MPM0 net11 A VDD VNW pm1p2_svt_lp W=2.36e-6 L=60e-9 MR=1
.ENDS
.SUBCKT BUFX12_9TSVT A VDD VSS Y VNW VPW
MNM1 Y net11 VSS VPW nm1p2_svt_lp W=5.64e-6 L=60e-9 MR=1
MNM0 net11 A VSS VPW nm1p2_svt_lp W=1.88e-6 L=60e-9 MR=1
MPM1 Y net11 VDD VNW pm1p2_svt_lp W=7.08e-6 L=60e-9 MR=1
MPM0 net11 A VDD VNW pm1p2_svt_lp W=2.36e-6 L=60e-9 MR=1
.ENDS
.SUBCKT BUFX16_9TSVT A VDD VSS Y VNW VPW
MNM1 Y net11 VSS VPW nm1p2_svt_lp W=7.52e-6 L=60e-9 MR=1
MNM0 net11 A VSS VPW nm1p2_svt_lp W=2.35e-6 L=60e-9 MR=1
MPM1 Y net11 VDD VNW pm1p2_svt_lp W=9.44e-6 L=60e-9 MR=1
MPM0 net11 A VDD VNW pm1p2_svt_lp W=2.95e-6 L=60e-9 MR=1
.ENDS
.SUBCKT BUFX1_9TSVT A VDD VSS Y VNW VPW
MNM1 Y net11 VSS VPW nm1p2_svt_lp W=470e-9 L=60e-9 MR=1
MNM0 net11 A VSS VPW nm1p2_svt_lp W=230e-9 L=60e-9 MR=1
MPM1 Y net11 VDD VNW pm1p2_svt_lp W=590e-9 L=60e-9 MR=1
MPM0 net11 A VDD VNW pm1p2_svt_lp W=300e-9 L=60e-9 MR=1
.ENDS
.SUBCKT BUFX24_9TSVT A VDD VSS Y VNW VPW
MNM1 Y net11 VSS VPW nm1p2_svt_lp W=11.28e-6 L=60e-9 MR=1
MNM0 net11 A VSS VPW nm1p2_svt_lp W=3.29e-6 L=60e-9 MR=1
MPM1 Y net11 VDD VNW pm1p2_svt_lp W=14.16e-6 L=60e-9 MR=1
MPM0 net11 A VDD VNW pm1p2_svt_lp W=4.13e-6 L=60e-9 MR=1
.ENDS
.SUBCKT BUFX2_9TSVT A VDD VSS Y VNW VPW
MNM1 Y net11 VSS VPW nm1p2_svt_lp W=940e-9 L=60e-9 MR=1
MNM0 net11 A VSS VPW nm1p2_svt_lp W=470e-9 L=60e-9 MR=1
MPM1 Y net11 VDD VNW pm1p2_svt_lp W=1.18e-6 L=60e-9 MR=1
MPM0 net11 A VDD VNW pm1p2_svt_lp W=590e-9 L=60e-9 MR=1
.ENDS
.SUBCKT BUFX3_9TSVT A VDD VSS Y VNW VPW
MNM1 Y net11 VSS VPW nm1p2_svt_lp W=1.41e-6 L=60e-9 MR=1
MNM0 net11 A VSS VPW nm1p2_svt_lp W=470e-9 L=60e-9 MR=1
MPM1 Y net11 VDD VNW pm1p2_svt_lp W=1.77e-6 L=60e-9 MR=1
MPM0 net11 A VDD VNW pm1p2_svt_lp W=590e-9 L=60e-9 MR=1
.ENDS
.SUBCKT BUFX4_9TSVT A VDD VSS Y VNW VPW
MNM1 Y net11 VSS VPW nm1p2_svt_lp W=1.88e-6 L=60e-9 MR=1
MNM0 net11 A VSS VPW nm1p2_svt_lp W=940e-9 L=60e-9 MR=1
MPM1 Y net11 VDD VNW pm1p2_svt_lp W=2.36e-6 L=60e-9 MR=1
MPM0 net11 A VDD VNW pm1p2_svt_lp W=1.18e-6 L=60e-9 MR=1
.ENDS
.SUBCKT BUFX5_9TSVT A VDD VSS Y VNW VPW
MNM1 Y net11 VSS VPW nm1p2_svt_lp W=2.35e-6 L=60e-9 MR=1
MNM0 net11 A VSS VPW nm1p2_svt_lp W=940e-9 L=60e-9 MR=1
MPM1 Y net11 VDD VNW pm1p2_svt_lp W=2.95e-6 L=60e-9 MR=1
MPM0 net11 A VDD VNW pm1p2_svt_lp W=1.18e-6 L=60e-9 MR=1
.ENDS
.SUBCKT BUFX6_9TSVT A VDD VSS Y VNW VPW
MNM1 Y net11 VSS VPW nm1p2_svt_lp W=2.82e-6 L=60e-9 MR=1
MNM0 net11 A VSS VPW nm1p2_svt_lp W=940e-9 L=60e-9 MR=1
MPM1 Y net11 VDD VNW pm1p2_svt_lp W=3.54e-6 L=60e-9 MR=1
MPM0 net11 A VDD VNW pm1p2_svt_lp W=1.18e-6 L=60e-9 MR=1
.ENDS
.SUBCKT BUFX8_9TSVT A VDD VSS Y VNW VPW
MNM1 Y net11 VSS VPW nm1p2_svt_lp W=3.76e-6 L=60e-9 MR=1
MNM0 net11 A VSS VPW nm1p2_svt_lp W=1.41e-6 L=60e-9 MR=1
MPM1 Y net11 VDD VNW pm1p2_svt_lp W=4.72e-6 L=60e-9 MR=1
MPM0 net11 A VDD VNW pm1p2_svt_lp W=1.77e-6 L=60e-9 MR=1
.ENDS
.SUBCKT CKGTNX0P5_9TSVT CKN E QN TE VDD VSS VNW VPW
MNM11 QN net32 VSS VPW nm1p2_svt_lp W=230e-9 L=60e-9 MR=1
MNM10 net32 net27 VSS VPW nm1p2_svt_lp W=230e-9 L=60e-9 MR=1
MNM9 net32 CKN VSS VPW nm1p2_svt_lp W=230e-9 L=60e-9 MR=1
MNM8 net27 net24 VSS VPW nm1p2_svt_lp W=230e-9 L=60e-9 MR=1
MNM6 net44 net24 VSS VPW nm1p2_svt_lp W=150e-9 L=60e-9 MR=1
MNM7 net18 cknn net44 VPW nm1p2_svt_lp W=150e-9 L=60e-9 MR=1
MNM5 net24 net18 VSS VPW nm1p2_svt_lp W=230e-9 L=60e-9 MR=1
MNM2 net39 TE VSS VPW nm1p2_svt_lp W=230e-9 L=60e-9 MR=1
MNM3 net39 E VSS VPW nm1p2_svt_lp W=230e-9 L=60e-9 MR=1
MNM4 net18 ckb net39 VPW nm1p2_svt_lp W=230e-9 L=60e-9 MR=1
MNM1 ckb cknn VSS VPW nm1p2_svt_lp W=230e-9 L=60e-9 MR=1
MNM0 cknn CKN VSS VPW nm1p2_svt_lp W=230e-9 L=60e-9 MR=1
MPM11 QN net32 VDD VNW pm1p2_svt_lp W=300e-9 L=60e-9 MR=1
MPM10 net43 net27 VDD VNW pm1p2_svt_lp W=300e-9 L=60e-9 MR=1
MPM9 net32 CKN net43 VNW pm1p2_svt_lp W=300e-9 L=60e-9 MR=1
MPM8 net27 net24 VDD VNW pm1p2_svt_lp W=300e-9 L=60e-9 MR=1
MPM7 net18 ckb net45 VNW pm1p2_svt_lp W=150e-9 L=60e-9 MR=1
MPM6 net45 net24 VDD VNW pm1p2_svt_lp W=150e-9 L=60e-9 MR=1
MPM5 net24 net18 VDD VNW pm1p2_svt_lp W=300e-9 L=60e-9 MR=1
MPM4 net18 cknn net46 VNW pm1p2_svt_lp W=300e-9 L=60e-9 MR=1
MPM3 net46 E net47 VNW pm1p2_svt_lp W=300e-9 L=60e-9 MR=1
MPM2 net47 TE VDD VNW pm1p2_svt_lp W=300e-9 L=60e-9 MR=1
MPM1 ckb cknn VDD VNW pm1p2_svt_lp W=300e-9 L=60e-9 MR=1
MPM0 cknn CKN VDD VNW pm1p2_svt_lp W=300e-9 L=60e-9 MR=1
.ENDS
.SUBCKT CKGTNX1_9TSVT CKN E QN TE VDD VSS VNW VPW
MNM11 QN net32 VSS VPW nm1p2_svt_lp W=470e-9 L=60e-9 MR=1
MNM10 net32 net27 VSS VPW nm1p2_svt_lp W=470e-9 L=60e-9 MR=1
MNM9 net32 CKN VSS VPW nm1p2_svt_lp W=470e-9 L=60e-9 MR=1
MNM8 net27 net24 VSS VPW nm1p2_svt_lp W=470e-9 L=60e-9 MR=1
MNM6 net44 net24 VSS VPW nm1p2_svt_lp W=150e-9 L=60e-9 MR=1
MNM7 net18 cknn net44 VPW nm1p2_svt_lp W=150e-9 L=60e-9 MR=1
MNM5 net24 net18 VSS VPW nm1p2_svt_lp W=470e-9 L=60e-9 MR=1
MNM2 net39 TE VSS VPW nm1p2_svt_lp W=470e-9 L=60e-9 MR=1
MNM3 net39 E VSS VPW nm1p2_svt_lp W=470e-9 L=60e-9 MR=1
MNM4 net18 ckb net39 VPW nm1p2_svt_lp W=470e-9 L=60e-9 MR=1
MNM1 ckb cknn VSS VPW nm1p2_svt_lp W=230e-9 L=60e-9 MR=1
MNM0 cknn CKN VSS VPW nm1p2_svt_lp W=230e-9 L=60e-9 MR=1
MPM11 QN net32 VDD VNW pm1p2_svt_lp W=590e-9 L=60e-9 MR=1
MPM10 net43 net27 VDD VNW pm1p2_svt_lp W=590e-9 L=60e-9 MR=1
MPM9 net32 CKN net43 VNW pm1p2_svt_lp W=590e-9 L=60e-9 MR=1
MPM8 net27 net24 VDD VNW pm1p2_svt_lp W=590e-9 L=60e-9 MR=1
MPM7 net18 ckb net45 VNW pm1p2_svt_lp W=150e-9 L=60e-9 MR=1
MPM6 net45 net24 VDD VNW pm1p2_svt_lp W=150e-9 L=60e-9 MR=1
MPM5 net24 net18 VDD VNW pm1p2_svt_lp W=590e-9 L=60e-9 MR=1
MPM4 net18 cknn net46 VNW pm1p2_svt_lp W=590e-9 L=60e-9 MR=1
MPM3 net46 E net47 VNW pm1p2_svt_lp W=590e-9 L=60e-9 MR=1
MPM2 net47 TE VDD VNW pm1p2_svt_lp W=590e-9 L=60e-9 MR=1
MPM1 ckb cknn VDD VNW pm1p2_svt_lp W=300e-9 L=60e-9 MR=1
MPM0 cknn CKN VDD VNW pm1p2_svt_lp W=300e-9 L=60e-9 MR=1
.ENDS
.SUBCKT CKGTNX2_9TSVT CKN E QN TE VDD VSS VNW VPW
MNM11 QN net32 VSS VPW nm1p2_svt_lp W=940e-9 L=60e-9 MR=1
MNM10 net32 net27 VSS VPW nm1p2_svt_lp W=470e-9 L=60e-9 MR=1
MNM9 net32 CKN VSS VPW nm1p2_svt_lp W=470e-9 L=60e-9 MR=1
MNM8 net27 net24 VSS VPW nm1p2_svt_lp W=470e-9 L=60e-9 MR=1
MNM6 net44 net24 VSS VPW nm1p2_svt_lp W=150e-9 L=60e-9 MR=1
MNM7 net18 cknn net44 VPW nm1p2_svt_lp W=150e-9 L=60e-9 MR=1
MNM5 net24 net18 VSS VPW nm1p2_svt_lp W=470e-9 L=60e-9 MR=1
MNM2 net39 TE VSS VPW nm1p2_svt_lp W=470e-9 L=60e-9 MR=1
MNM3 net39 E VSS VPW nm1p2_svt_lp W=470e-9 L=60e-9 MR=1
MNM4 net18 ckb net39 VPW nm1p2_svt_lp W=470e-9 L=60e-9 MR=1
MNM1 ckb cknn VSS VPW nm1p2_svt_lp W=230e-9 L=60e-9 MR=1
MNM0 cknn CKN VSS VPW nm1p2_svt_lp W=230e-9 L=60e-9 MR=1
MPM11 QN net32 VDD VNW pm1p2_svt_lp W=1.18e-6 L=60e-9 MR=1
MPM10 net43 net27 VDD VNW pm1p2_svt_lp W=590e-9 L=60e-9 MR=1
MPM9 net32 CKN net43 VNW pm1p2_svt_lp W=590e-9 L=60e-9 MR=1
MPM8 net27 net24 VDD VNW pm1p2_svt_lp W=590e-9 L=60e-9 MR=1
MPM7 net18 ckb net45 VNW pm1p2_svt_lp W=150e-9 L=60e-9 MR=1
MPM6 net45 net24 VDD VNW pm1p2_svt_lp W=150e-9 L=60e-9 MR=1
MPM5 net24 net18 VDD VNW pm1p2_svt_lp W=590e-9 L=60e-9 MR=1
MPM4 net18 cknn net46 VNW pm1p2_svt_lp W=590e-9 L=60e-9 MR=1
MPM3 net46 E net47 VNW pm1p2_svt_lp W=590e-9 L=60e-9 MR=1
MPM2 net47 TE VDD VNW pm1p2_svt_lp W=590e-9 L=60e-9 MR=1
MPM1 ckb cknn VDD VNW pm1p2_svt_lp W=300e-9 L=60e-9 MR=1
MPM0 cknn CKN VDD VNW pm1p2_svt_lp W=300e-9 L=60e-9 MR=1
.ENDS
.SUBCKT CKGTNX4_9TSVT CKN E QN TE VDD VSS VNW VPW
MNM11 QN net32 VSS VPW nm1p2_svt_lp W=1.88e-6 L=60e-9 MR=1
MNM10 net32 net27 VSS VPW nm1p2_svt_lp W=940e-9 L=60e-9 MR=1
MNM9 net32 CKN VSS VPW nm1p2_svt_lp W=940e-9 L=60e-9 MR=1
MNM8 net27 net24 VSS VPW nm1p2_svt_lp W=470e-9 L=60e-9 MR=1
MNM6 net44 net24 VSS VPW nm1p2_svt_lp W=150e-9 L=60e-9 MR=1
MNM7 net18 cknn net44 VPW nm1p2_svt_lp W=150e-9 L=60e-9 MR=1
MNM5 net24 net18 VSS VPW nm1p2_svt_lp W=470e-9 L=60e-9 MR=1
MNM2 net39 TE VSS VPW nm1p2_svt_lp W=470e-9 L=60e-9 MR=1
MNM3 net39 E VSS VPW nm1p2_svt_lp W=470e-9 L=60e-9 MR=1
MNM4 net18 ckb net39 VPW nm1p2_svt_lp W=470e-9 L=60e-9 MR=1
MNM1 ckb cknn VSS VPW nm1p2_svt_lp W=230n L=60n MR=1
MNM0 cknn CKN VSS VPW nm1p2_svt_lp W=230n L=60n MR=1
MPM11 QN net32 VDD VNW pm1p2_svt_lp W=2.36e-6 L=60e-9 MR=1
MPM10 net43 net27 VDD VNW pm1p2_svt_lp W=1.18e-6 L=60e-9 MR=1
MPM9 net32 CKN net43 VNW pm1p2_svt_lp W=1.18e-6 L=60e-9 MR=1
MPM8 net27 net24 VDD VNW pm1p2_svt_lp W=590e-9 L=60e-9 MR=1
MPM7 net18 ckb net45 VNW pm1p2_svt_lp W=150e-9 L=60e-9 MR=1
MPM6 net45 net24 VDD VNW pm1p2_svt_lp W=150e-9 L=60e-9 MR=1
MPM5 net24 net18 VDD VNW pm1p2_svt_lp W=590e-9 L=60e-9 MR=1
MPM4 net18 cknn net46 VNW pm1p2_svt_lp W=590e-9 L=60e-9 MR=1
MPM3 net46 E net47 VNW pm1p2_svt_lp W=590e-9 L=60e-9 MR=1
MPM2 net47 TE VDD VNW pm1p2_svt_lp W=590e-9 L=60e-9 MR=1
MPM1 ckb cknn VDD VNW pm1p2_svt_lp W=300n L=60n MR=1
MPM0 cknn CKN VDD VNW pm1p2_svt_lp W=300n L=60n MR=1
.ENDS
.SUBCKT CKGTNX8_9TSVT CKN E QN TE VDD VSS VNW VPW
MNM11 QN net32 VSS VPW nm1p2_svt_lp W=3.76e-6 L=60e-9 MR=1
MNM10 net32 net27 VSS VPW nm1p2_svt_lp W=1.41e-6 L=60e-9 MR=1
MNM9 net32 CKN VSS VPW nm1p2_svt_lp W=1.41e-6 L=60e-9 MR=1
MNM8 net27 net24 VSS VPW nm1p2_svt_lp W=470e-9 L=60e-9 MR=1
MNM6 net44 net24 VSS VPW nm1p2_svt_lp W=150e-9 L=60e-9 MR=1
MNM7 net18 cknn net44 VPW nm1p2_svt_lp W=150e-9 L=60e-9 MR=1
MNM5 net24 net18 VSS VPW nm1p2_svt_lp W=470e-9 L=60e-9 MR=1
MNM2 net39 TE VSS VPW nm1p2_svt_lp W=470e-9 L=60e-9 MR=1
MNM3 net39 E VSS VPW nm1p2_svt_lp W=470e-9 L=60e-9 MR=1
MNM4 net18 ckb net39 VPW nm1p2_svt_lp W=470e-9 L=60e-9 MR=1
MNM1 ckb cknn VSS VPW nm1p2_svt_lp W=230n L=60n MR=1
MNM0 cknn CKN VSS VPW nm1p2_svt_lp W=230n L=60n MR=1
MPM11 QN net32 VDD VNW pm1p2_svt_lp W=4.72e-6 L=60e-9 MR=1
MPM10 net43 net27 VDD VNW pm1p2_svt_lp W=1.77e-6 L=60e-9 MR=1
MPM9 net32 CKN net43 VNW pm1p2_svt_lp W=1.77e-6 L=60e-9 MR=1
MPM8 net27 net24 VDD VNW pm1p2_svt_lp W=590e-9 L=60e-9 MR=1
MPM7 net18 ckb net45 VNW pm1p2_svt_lp W=150e-9 L=60e-9 MR=1
MPM6 net45 net24 VDD VNW pm1p2_svt_lp W=150e-9 L=60e-9 MR=1
MPM5 net24 net18 VDD VNW pm1p2_svt_lp W=590e-9 L=60e-9 MR=1
MPM4 net18 cknn net46 VNW pm1p2_svt_lp W=590e-9 L=60e-9 MR=1
MPM3 net46 E net47 VNW pm1p2_svt_lp W=590e-9 L=60e-9 MR=1
MPM2 net47 TE VDD VNW pm1p2_svt_lp W=590e-9 L=60e-9 MR=1
MPM1 ckb cknn VDD VNW pm1p2_svt_lp W=300n L=60n MR=1
MPM0 cknn CKN VDD VNW pm1p2_svt_lp W=300n L=60n MR=1
.ENDS
.SUBCKT CKGTX0P5_9TSVT CK E Q TE VDD VSS VNW VPW
MNM10 Q net28 VSS VPW nm1p2_svt_lp W=230e-9 L=60e-9 MR=1
MNM9 net39 net24 VSS VPW nm1p2_svt_lp W=230e-9 L=60e-9 MR=1
MNM8 net28 CK net39 VPW nm1p2_svt_lp W=230e-9 L=60e-9 MR=1
MNM6 net40 net24 VSS VPW nm1p2_svt_lp W=150e-9 L=60e-9 MR=1
MNM7 net18 ckb net40 VPW nm1p2_svt_lp W=150e-9 L=60e-9 MR=1
MNM5 net24 net18 VSS VPW nm1p2_svt_lp W=230e-9 L=60e-9 MR=1
MNM2 net35 TE VSS VPW nm1p2_svt_lp W=230e-9 L=60e-9 MR=1
MNM3 net35 E VSS VPW nm1p2_svt_lp W=230e-9 L=60e-9 MR=1
MNM4 net18 ckn net35 VPW nm1p2_svt_lp W=230e-9 L=60e-9 MR=1
MNM1 ckb ckn VSS VPW nm1p2_svt_lp W=230e-9 L=60e-9 MR=1
MNM0 ckn CK VSS VPW nm1p2_svt_lp W=230e-9 L=60e-9 MR=1
MPM10 Q net28 VDD VNW pm1p2_svt_lp W=300e-9 L=60e-9 MR=1
MPM9 net28 net24 VDD VNW pm1p2_svt_lp W=300e-9 L=60e-9 MR=1
MPM8 net28 CK VDD VNW pm1p2_svt_lp W=300e-9 L=60e-9 MR=1
MPM7 net18 ckn net41 VNW pm1p2_svt_lp W=150e-9 L=60e-9 MR=1
MPM6 net41 net24 VDD VNW pm1p2_svt_lp W=150e-9 L=60e-9 MR=1
MPM5 net24 net18 VDD VNW pm1p2_svt_lp W=300e-9 L=60e-9 MR=1
MPM4 net18 ckb net42 VNW pm1p2_svt_lp W=300e-9 L=60e-9 MR=1
MPM3 net42 E net43 VNW pm1p2_svt_lp W=300e-9 L=60e-9 MR=1
MPM2 net43 TE VDD VNW pm1p2_svt_lp W=300e-9 L=60e-9 MR=1
MPM1 ckb ckn VDD VNW pm1p2_svt_lp W=300e-9 L=60e-9 MR=1
MPM0 ckn CK VDD VNW pm1p2_svt_lp W=300e-9 L=60e-9 MR=1
.ENDS
.SUBCKT CKGTX1_9TSVT CK E Q TE VDD VSS VNW VPW
MNM10 Q net28 VSS VPW nm1p2_svt_lp W=470e-9 L=60e-9 MR=1
MNM9 net39 net24 VSS VPW nm1p2_svt_lp W=470e-9 L=60e-9 MR=1
MNM8 net28 CK net39 VPW nm1p2_svt_lp W=470e-9 L=60e-9 MR=1
MNM6 net40 net24 VSS VPW nm1p2_svt_lp W=150e-9 L=60e-9 MR=1
MNM7 net18 ckb net40 VPW nm1p2_svt_lp W=150e-9 L=60e-9 MR=1
MNM5 net24 net18 VSS VPW nm1p2_svt_lp W=470e-9 L=60e-9 MR=1
MNM2 net35 TE VSS VPW nm1p2_svt_lp W=470e-9 L=60e-9 MR=1
MNM3 net35 E VSS VPW nm1p2_svt_lp W=470e-9 L=60e-9 MR=1
MNM4 net18 ckn net35 VPW nm1p2_svt_lp W=470e-9 L=60e-9 MR=1
MNM1 ckb ckn VSS VPW nm1p2_svt_lp W=230e-9 L=60e-9 MR=1
MNM0 ckn CK VSS VPW nm1p2_svt_lp W=230e-9 L=60e-9 MR=1
MPM10 Q net28 VDD VNW pm1p2_svt_lp W=590e-9 L=60e-9 MR=1
MPM9 net28 net24 VDD VNW pm1p2_svt_lp W=590e-9 L=60e-9 MR=1
MPM8 net28 CK VDD VNW pm1p2_svt_lp W=590e-9 L=60e-9 MR=1
MPM7 net18 ckn net41 VNW pm1p2_svt_lp W=150e-9 L=60e-9 MR=1
MPM6 net41 net24 VDD VNW pm1p2_svt_lp W=150e-9 L=60e-9 MR=1
MPM5 net24 net18 VDD VNW pm1p2_svt_lp W=590e-9 L=60e-9 MR=1
MPM4 net18 ckb net42 VNW pm1p2_svt_lp W=590e-9 L=60e-9 MR=1
MPM3 net42 E net43 VNW pm1p2_svt_lp W=590e-9 L=60e-9 MR=1
MPM2 net43 TE VDD VNW pm1p2_svt_lp W=590e-9 L=60e-9 MR=1
MPM1 ckb ckn VDD VNW pm1p2_svt_lp W=300e-9 L=60e-9 MR=1
MPM0 ckn CK VDD VNW pm1p2_svt_lp W=300e-9 L=60e-9 MR=1
.ENDS
.SUBCKT CKGTX2_9TSVT CK E Q TE VDD VSS VNW VPW
MNM10 Q net28 VSS VPW nm1p2_svt_lp W=940e-9 L=60e-9 MR=1
MNM9 net39 net24 VSS VPW nm1p2_svt_lp W=470e-9 L=60e-9 MR=1
MNM8 net28 CK net39 VPW nm1p2_svt_lp W=470e-9 L=60e-9 MR=1
MNM6 net40 net24 VSS VPW nm1p2_svt_lp W=150e-9 L=60e-9 MR=1
MNM7 net18 ckb net40 VPW nm1p2_svt_lp W=150e-9 L=60e-9 MR=1
MNM5 net24 net18 VSS VPW nm1p2_svt_lp W=470e-9 L=60e-9 MR=1
MNM2 net35 TE VSS VPW nm1p2_svt_lp W=470e-9 L=60e-9 MR=1
MNM3 net35 E VSS VPW nm1p2_svt_lp W=470e-9 L=60e-9 MR=1
MNM4 net18 ckn net35 VPW nm1p2_svt_lp W=470e-9 L=60e-9 MR=1
MNM1 ckb ckn VSS VPW nm1p2_svt_lp W=230e-9 L=60e-9 MR=1
MNM0 ckn CK VSS VPW nm1p2_svt_lp W=230e-9 L=60e-9 MR=1
MPM10 Q net28 VDD VNW pm1p2_svt_lp W=1.18e-6 L=60e-9 MR=1
MPM9 net28 net24 VDD VNW pm1p2_svt_lp W=590e-9 L=60e-9 MR=1
MPM8 net28 CK VDD VNW pm1p2_svt_lp W=590e-9 L=60e-9 MR=1
MPM7 net18 ckn net41 VNW pm1p2_svt_lp W=150e-9 L=60e-9 MR=1
MPM6 net41 net24 VDD VNW pm1p2_svt_lp W=150e-9 L=60e-9 MR=1
MPM5 net24 net18 VDD VNW pm1p2_svt_lp W=590e-9 L=60e-9 MR=1
MPM4 net18 ckb net42 VNW pm1p2_svt_lp W=590e-9 L=60e-9 MR=1
MPM3 net42 E net43 VNW pm1p2_svt_lp W=590e-9 L=60e-9 MR=1
MPM2 net43 TE VDD VNW pm1p2_svt_lp W=590e-9 L=60e-9 MR=1
MPM1 ckb ckn VDD VNW pm1p2_svt_lp W=300e-9 L=60e-9 MR=1
MPM0 ckn CK VDD VNW pm1p2_svt_lp W=300e-9 L=60e-9 MR=1
.ENDS
.SUBCKT CKGTX4_9TSVT CK E Q TE VDD VSS VNW VPW
MNM10 Q net28 VSS VPW nm1p2_svt_lp W=1.88e-6 L=60e-9 MR=1
MNM9 net39 net24 VSS VPW nm1p2_svt_lp W=940e-9 L=60e-9 MR=1
MNM8 net28 CK net39 VPW nm1p2_svt_lp W=940e-9 L=60e-9 MR=1
MNM6 net40 net24 VSS VPW nm1p2_svt_lp W=150e-9 L=60e-9 MR=1
MNM7 net18 ckb net40 VPW nm1p2_svt_lp W=150e-9 L=60e-9 MR=1
MNM5 net24 net18 VSS VPW nm1p2_svt_lp W=470e-9 L=60e-9 MR=1
MNM2 net35 TE VSS VPW nm1p2_svt_lp W=470e-9 L=60e-9 MR=1
MNM3 net35 E VSS VPW nm1p2_svt_lp W=470e-9 L=60e-9 MR=1
MNM4 net18 ckn net35 VPW nm1p2_svt_lp W=470e-9 L=60e-9 MR=1
MNM1 ckb ckn VSS VPW nm1p2_svt_lp W=230n L=60n MR=1
MNM0 ckn CK VSS VPW nm1p2_svt_lp W=230n L=60n MR=1
MPM10 Q net28 VDD VNW pm1p2_svt_lp W=2.36e-6 L=60e-9 MR=1
MPM9 net28 net24 VDD VNW pm1p2_svt_lp W=1.18e-6 L=60e-9 MR=1
MPM8 net28 CK VDD VNW pm1p2_svt_lp W=1.18e-6 L=60e-9 MR=1
MPM7 net18 ckn net41 VNW pm1p2_svt_lp W=150e-9 L=60e-9 MR=1
MPM6 net41 net24 VDD VNW pm1p2_svt_lp W=150e-9 L=60e-9 MR=1
MPM5 net24 net18 VDD VNW pm1p2_svt_lp W=590e-9 L=60e-9 MR=1
MPM4 net18 ckb net42 VNW pm1p2_svt_lp W=590e-9 L=60e-9 MR=1
MPM3 net42 E net43 VNW pm1p2_svt_lp W=590e-9 L=60e-9 MR=1
MPM2 net43 TE VDD VNW pm1p2_svt_lp W=590e-9 L=60e-9 MR=1
MPM1 ckb ckn VDD VNW pm1p2_svt_lp W=300n L=60n MR=1
MPM0 ckn CK VDD VNW pm1p2_svt_lp W=300n L=60n MR=1
.ENDS
.SUBCKT CKGTX8_9TSVT CK E Q TE VDD VSS VNW VPW
MNM10 Q net28 VSS VPW nm1p2_svt_lp W=3.76e-6 L=60e-9 MR=1
MNM9 net39 net24 VSS VPW nm1p2_svt_lp W=1.41e-6 L=60e-9 MR=1
MNM8 net28 CK net39 VPW nm1p2_svt_lp W=1.41e-6 L=60e-9 MR=1
MNM6 net40 net24 VSS VPW nm1p2_svt_lp W=150e-9 L=60e-9 MR=1
MNM7 net18 ckb net40 VPW nm1p2_svt_lp W=150e-9 L=60e-9 MR=1
MNM5 net24 net18 VSS VPW nm1p2_svt_lp W=470e-9 L=60e-9 MR=1
MNM2 net35 TE VSS VPW nm1p2_svt_lp W=470e-9 L=60e-9 MR=1
MNM3 net35 E VSS VPW nm1p2_svt_lp W=470e-9 L=60e-9 MR=1
MNM4 net18 ckn net35 VPW nm1p2_svt_lp W=470e-9 L=60e-9 MR=1
MNM1 ckb ckn VSS VPW nm1p2_svt_lp W=230n L=60n MR=1
MNM0 ckn CK VSS VPW nm1p2_svt_lp W=230n L=60n MR=1
MPM10 Q net28 VDD VNW pm1p2_svt_lp W=4.72e-6 L=60e-9 MR=1
MPM9 net28 net24 VDD VNW pm1p2_svt_lp W=1.77e-6 L=60e-9 MR=1
MPM8 net28 CK VDD VNW pm1p2_svt_lp W=1.77e-6 L=60e-9 MR=1
MPM7 net18 ckn net41 VNW pm1p2_svt_lp W=150e-9 L=60e-9 MR=1
MPM6 net41 net24 VDD VNW pm1p2_svt_lp W=150e-9 L=60e-9 MR=1
MPM5 net24 net18 VDD VNW pm1p2_svt_lp W=590e-9 L=60e-9 MR=1
MPM4 net18 ckb net42 VNW pm1p2_svt_lp W=590e-9 L=60e-9 MR=1
MPM3 net42 E net43 VNW pm1p2_svt_lp W=590e-9 L=60e-9 MR=1
MPM2 net43 TE VDD VNW pm1p2_svt_lp W=590e-9 L=60e-9 MR=1
MPM1 ckb ckn VDD VNW pm1p2_svt_lp W=300n L=60n MR=1
MPM0 ckn CK VDD VNW pm1p2_svt_lp W=300n L=60n MR=1
.ENDS
.SUBCKT CLKAND2X0P5_9TSVT A B VDD VSS Y VNW VPW
MNM2 Y net13 VSS VPW nm1p2_svt_lp W=180e-9 L=60e-9 MR=1
MNM1 net19 B VSS VPW nm1p2_svt_lp W=210e-9 L=60e-9 MR=1
MNM0 net13 A net19 VPW nm1p2_svt_lp W=210e-9 L=60e-9 MR=1
MPM2 Y net13 VDD VNW pm1p2_svt_lp W=300e-9 L=60e-9 MR=1
MPM1 net13 B VDD VNW pm1p2_svt_lp W=300e-9 L=60e-9 MR=1
MPM0 net13 A VDD VNW pm1p2_svt_lp W=300e-9 L=60e-9 MR=1
.ENDS
.SUBCKT CLKAND2X1_9TSVT A B VDD VSS Y VNW VPW
MNM2 Y net13 VSS VPW nm1p2_svt_lp W=350e-9 L=60e-9 MR=1
MNM1 net19 B VSS VPW nm1p2_svt_lp W=210e-9 L=60e-9 MR=1
MNM0 net13 A net19 VPW nm1p2_svt_lp W=210e-9 L=60e-9 MR=1
MPM2 Y net13 VDD VNW pm1p2_svt_lp W=590e-9 L=60e-9 MR=1
MPM1 net13 B VDD VNW pm1p2_svt_lp W=300e-9 L=60e-9 MR=1
MPM0 net13 A VDD VNW pm1p2_svt_lp W=300e-9 L=60e-9 MR=1
.ENDS
.SUBCKT CLKAND2X2_9TSVT A B VDD VSS Y VNW VPW
MNM2 Y net13 VSS VPW nm1p2_svt_lp W=700e-9 L=60e-9 MR=1
MNM1 net19 B VSS VPW nm1p2_svt_lp W=410e-9 L=60e-9 MR=1
MNM0 net13 A net19 VPW nm1p2_svt_lp W=410e-9 L=60e-9 MR=1
MPM2 Y net13 VDD VNW pm1p2_svt_lp W=1.18e-6 L=60e-9 MR=1
MPM1 net13 B VDD VNW pm1p2_svt_lp W=590e-9 L=60e-9 MR=1
MPM0 net13 A VDD VNW pm1p2_svt_lp W=590e-9 L=60e-9 MR=1
.ENDS
.SUBCKT CLKAND2X3_9TSVT A B VDD VSS Y VNW VPW
MNM2 Y net13 VSS VPW nm1p2_svt_lp W=1.05e-6 L=60e-9 MR=1
MNM1 net19 B VSS VPW nm1p2_svt_lp W=410e-9 L=60e-9 MR=1
MNM0 net13 A net19 VPW nm1p2_svt_lp W=410e-9 L=60e-9 MR=1
MPM2 Y net13 VDD VNW pm1p2_svt_lp W=1.77e-6 L=60e-9 MR=1
MPM1 net13 B VDD VNW pm1p2_svt_lp W=590e-9 L=60e-9 MR=1
MPM0 net13 A VDD VNW pm1p2_svt_lp W=590e-9 L=60e-9 MR=1
.ENDS
.SUBCKT CLKAND2X4_9TSVT A B VDD VSS Y VNW VPW
MNM2 Y net13 VSS VPW nm1p2_svt_lp W=1.4e-6 L=60e-9 MR=1
MNM1 net19 B VSS VPW nm1p2_svt_lp W=820e-9 L=60e-9 MR=1
MNM0 net13 A net19 VPW nm1p2_svt_lp W=820e-9 L=60e-9 MR=1
MPM2 Y net13 VDD VNW pm1p2_svt_lp W=2.36e-6 L=60e-9 MR=1
MPM1 net13 B VDD VNW pm1p2_svt_lp W=1.18e-6 L=60e-9 MR=1
MPM0 net13 A VDD VNW pm1p2_svt_lp W=1.18e-6 L=60e-9 MR=1
.ENDS
.SUBCKT CLKAND2X6_9TSVT A B VDD VSS Y VNW VPW
MNM2 Y net13 VSS VPW nm1p2_svt_lp W=2.1e-6 L=60e-9 MR=1
MNM1 net19 B VSS VPW nm1p2_svt_lp W=820e-9 L=60e-9 MR=1
MNM0 net13 A net19 VPW nm1p2_svt_lp W=820e-9 L=60e-9 MR=1
MPM2 Y net13 VDD VNW pm1p2_svt_lp W=3.54e-6 L=60e-9 MR=1
MPM1 net13 B VDD VNW pm1p2_svt_lp W=1.18e-6 L=60e-9 MR=1
MPM0 net13 A VDD VNW pm1p2_svt_lp W=1.18e-6 L=60e-9 MR=1
.ENDS
.SUBCKT CLKAND2X8_9TSVT A B VDD VSS Y VNW VPW
MNM2 Y net13 VSS VPW nm1p2_svt_lp W=2.8e-6 L=60e-9 MR=1
MNM1 net19 B VSS VPW nm1p2_svt_lp W=1.23e-6 L=60e-9 MR=1
MNM0 net13 A net19 VPW nm1p2_svt_lp W=1.23e-6 L=60e-9 MR=1
MPM2 Y net13 VDD VNW pm1p2_svt_lp W=4.72e-6 L=60e-9 MR=1
MPM1 net13 B VDD VNW pm1p2_svt_lp W=1.77e-6 L=60e-9 MR=1
MPM0 net13 A VDD VNW pm1p2_svt_lp W=1.77e-6 L=60e-9 MR=1
.ENDS
.SUBCKT CLKBUFX0P5_9TSVT A VDD VSS Y VNW VPW
MNM1 Y net11 VSS VPW nm1p2_svt_lp W=180e-9 L=60e-9 MR=1
MNM0 net11 A VSS VPW nm1p2_svt_lp W=180e-9 L=60e-9 MR=1
MPM1 Y net11 VDD VNW pm1p2_svt_lp W=300e-9 L=60e-9 MR=1
MPM0 net11 A VDD VNW pm1p2_svt_lp W=300e-9 L=60e-9 MR=1
.ENDS
.SUBCKT CLKBUFX10_9TSVT A VDD VSS Y VNW VPW
MNM1 Y net11 VSS VPW nm1p2_svt_lp W=3.5e-6 L=60e-9 MR=1
MNM0 net11 A VSS VPW nm1p2_svt_lp W=1.4e-6 L=60e-9 MR=1
MPM1 Y net11 VDD VNW pm1p2_svt_lp W=5.9e-6 L=60e-9 MR=1
MPM0 net11 A VDD VNW pm1p2_svt_lp W=2.36e-6 L=60e-9 MR=1
.ENDS
.SUBCKT CLKBUFX12_9TSVT A VDD VSS Y VNW VPW
MNM1 Y net11 VSS VPW nm1p2_svt_lp W=4.2e-6 L=60e-9 MR=1
MNM0 net11 A VSS VPW nm1p2_svt_lp W=1.4e-6 L=60e-9 MR=1
MPM1 Y net11 VDD VNW pm1p2_svt_lp W=7.08e-6 L=60e-9 MR=1
MPM0 net11 A VDD VNW pm1p2_svt_lp W=2.36e-6 L=60e-9 MR=1
.ENDS
.SUBCKT CLKBUFX16_9TSVT A VDD VSS Y VNW VPW
MNM1 Y net11 VSS VPW nm1p2_svt_lp W=5.6e-6 L=60e-9 MR=1
MNM0 net11 A VSS VPW nm1p2_svt_lp W=1.75e-6 L=60e-9 MR=1
MPM1 Y net11 VDD VNW pm1p2_svt_lp W=9.44e-6 L=60e-9 MR=1
MPM0 net11 A VDD VNW pm1p2_svt_lp W=2.95e-6 L=60e-9 MR=1
.ENDS
.SUBCKT CLKBUFX1_9TSVT A VDD VSS Y VNW VPW
MNM1 Y net11 VSS VPW nm1p2_svt_lp W=350e-9 L=60e-9 MR=1
MNM0 net11 A VSS VPW nm1p2_svt_lp W=180e-9 L=60e-9 MR=1
MPM1 Y net11 VDD VNW pm1p2_svt_lp W=590e-9 L=60e-9 MR=1
MPM0 net11 A VDD VNW pm1p2_svt_lp W=300e-9 L=60e-9 MR=1
.ENDS
.SUBCKT CLKBUFX24_9TSVT A VDD VSS Y VNW VPW
MNM1 Y net11 VSS VPW nm1p2_svt_lp W=8.4e-6 L=60e-9 MR=1
MNM0 net11 A VSS VPW nm1p2_svt_lp W=2.45e-6 L=60e-9 MR=1
MPM1 Y net11 VDD VNW pm1p2_svt_lp W=14.16e-6 L=60e-9 MR=1
MPM0 net11 A VDD VNW pm1p2_svt_lp W=4.13e-6 L=60e-9 MR=1
.ENDS
.SUBCKT CLKBUFX2_9TSVT A VDD VSS Y VNW VPW
MNM1 Y net11 VSS VPW nm1p2_svt_lp W=700e-9 L=60e-9 MR=1
MNM0 net11 A VSS VPW nm1p2_svt_lp W=350e-9 L=60e-9 MR=1
MPM1 Y net11 VDD VNW pm1p2_svt_lp W=1.18e-6 L=60e-9 MR=1
MPM0 net11 A VDD VNW pm1p2_svt_lp W=590e-9 L=60e-9 MR=1
.ENDS
.SUBCKT CLKBUFX3_9TSVT A VDD VSS Y VNW VPW
MNM1 Y net11 VSS VPW nm1p2_svt_lp W=1.05e-6 L=60e-9 MR=1
MNM0 net11 A VSS VPW nm1p2_svt_lp W=350e-9 L=60e-9 MR=1
MPM1 Y net11 VDD VNW pm1p2_svt_lp W=1.77e-6 L=60e-9 MR=1
MPM0 net11 A VDD VNW pm1p2_svt_lp W=590e-9 L=60e-9 MR=1
.ENDS
.SUBCKT CLKBUFX4_9TSVT A VDD VSS Y VNW VPW
MNM1 Y net11 VSS VPW nm1p2_svt_lp W=1.4e-6 L=60e-9 MR=1
MNM0 net11 A VSS VPW nm1p2_svt_lp W=700e-9 L=60e-9 MR=1
MPM1 Y net11 VDD VNW pm1p2_svt_lp W=2.36e-6 L=60e-9 MR=1
MPM0 net11 A VDD VNW pm1p2_svt_lp W=1.18e-6 L=60e-9 MR=1
.ENDS
.SUBCKT CLKBUFX5_9TSVT A VDD VSS Y VNW VPW
MNM1 Y net11 VSS VPW nm1p2_svt_lp W=1.75e-6 L=60e-9 MR=1
MNM0 net11 A VSS VPW nm1p2_svt_lp W=700e-9 L=60e-9 MR=1
MPM1 Y net11 VDD VNW pm1p2_svt_lp W=2.95e-6 L=60e-9 MR=1
MPM0 net11 A VDD VNW pm1p2_svt_lp W=1.18e-6 L=60e-9 MR=1
.ENDS
.SUBCKT CLKBUFX6_9TSVT A VDD VSS Y VNW VPW
MNM1 Y net11 VSS VPW nm1p2_svt_lp W=2.1e-6 L=60e-9 MR=1
MNM0 net11 A VSS VPW nm1p2_svt_lp W=700e-9 L=60e-9 MR=1
MPM1 Y net11 VDD VNW pm1p2_svt_lp W=3.54e-6 L=60e-9 MR=1
MPM0 net11 A VDD VNW pm1p2_svt_lp W=1.18e-6 L=60e-9 MR=1
.ENDS
.SUBCKT CLKBUFX8_9TSVT A VDD VSS Y VNW VPW
MNM1 Y net11 VSS VPW nm1p2_svt_lp W=2.8e-6 L=60e-9 MR=1
MNM0 net11 A VSS VPW nm1p2_svt_lp W=1.05e-6 L=60e-9 MR=1
MPM1 Y net11 VDD VNW pm1p2_svt_lp W=4.72e-6 L=60e-9 MR=1
MPM0 net11 A VDD VNW pm1p2_svt_lp W=1.77e-6 L=60e-9 MR=1
.ENDS
.SUBCKT CLKINVX0P5_9TSVT A VDD VSS Y VNW VPW
MNM0 Y A VSS VPW nm1p2_svt_lp W=180e-9 L=60e-9 MR=1
MPM0 Y A VDD VNW pm1p2_svt_lp W=300e-9 L=60e-9 MR=1
.ENDS
.SUBCKT CLKINVX10_9TSVT A VDD VSS Y VNW VPW
MNM0 Y A VSS VPW nm1p2_svt_lp W=3.5e-6 L=60e-9 MR=1
MPM0 Y A VDD VNW pm1p2_svt_lp W=5.9e-6 L=60e-9 MR=1
.ENDS
.SUBCKT CLKINVX12_9TSVT A VDD VSS Y VNW VPW
MNM0 Y A VSS VPW nm1p2_svt_lp W=4.2e-6 L=60e-9 MR=1
MPM0 Y A VDD VNW pm1p2_svt_lp W=7.08e-6 L=60e-9 MR=1
.ENDS
.SUBCKT CLKINVX16_9TSVT A VDD VSS Y VNW VPW
MNM0 Y A VSS VPW nm1p2_svt_lp W=5.6e-6 L=60e-9 MR=1
MPM0 Y A VDD VNW pm1p2_svt_lp W=9.44e-6 L=60e-9 MR=1
.ENDS
.SUBCKT CLKINVX1_9TSVT A VDD VSS Y VNW VPW
MNM0 Y A VSS VPW nm1p2_svt_lp W=350e-9 L=60e-9 MR=1
MPM0 Y A VDD VNW pm1p2_svt_lp W=590e-9 L=60e-9 MR=1
.ENDS
.SUBCKT CLKINVX24_9TSVT A VDD VSS Y VNW VPW
MNM0 Y A VSS VPW nm1p2_svt_lp W=8.4e-6 L=60e-9 MR=1
MPM0 Y A VDD VNW pm1p2_svt_lp W=14.16e-6 L=60e-9 MR=1
.ENDS
.SUBCKT CLKINVX2_9TSVT A VDD VSS Y VNW VPW
MNM0 Y A VSS VPW nm1p2_svt_lp W=700e-9 L=60e-9 MR=1
MPM0 Y A VDD VNW pm1p2_svt_lp W=1.18e-6 L=60e-9 MR=1
.ENDS
.SUBCKT CLKINVX3_9TSVT A VDD VSS Y VNW VPW
MNM0 Y A VSS VPW nm1p2_svt_lp W=1.05e-6 L=60e-9 MR=1
MPM0 Y A VDD VNW pm1p2_svt_lp W=1.77e-6 L=60e-9 MR=1
.ENDS
.SUBCKT CLKINVX4_9TSVT A VDD VSS Y VNW VPW
MNM0 Y A VSS VPW nm1p2_svt_lp W=1.4e-6 L=60e-9 MR=1
MPM0 Y A VDD VNW pm1p2_svt_lp W=2.36e-6 L=60e-9 MR=1
.ENDS
.SUBCKT CLKINVX5_9TSVT A VDD VSS Y VNW VPW
MNM0 Y A VSS VPW nm1p2_svt_lp W=1.75e-6 L=60e-9 MR=1
MPM0 Y A VDD VNW pm1p2_svt_lp W=2.95e-6 L=60e-9 MR=1
.ENDS
.SUBCKT CLKINVX6_9TSVT A VDD VSS Y VNW VPW
MNM0 Y A VSS VPW nm1p2_svt_lp W=2.1e-6 L=60e-9 MR=1
MPM0 Y A VDD VNW pm1p2_svt_lp W=3.54e-6 L=60e-9 MR=1
.ENDS
.SUBCKT CLKINVX8_9TSVT A VDD VSS Y VNW VPW
MNM0 Y A VSS VPW nm1p2_svt_lp W=2.8e-6 L=60e-9 MR=1
MPM0 Y A VDD VNW pm1p2_svt_lp W=4.72e-6 L=60e-9 MR=1
.ENDS
.SUBCKT CLKMX2X0P5_9TSVT A B S VDD VSS Y VNW VPW
MNM5 SN S VSS VPW nm1p2_svt_lp W=180e-9 L=60e-9 MR=1
MNM4 Y net23 VSS VPW nm1p2_svt_lp W=180e-9 L=60e-9 MR=1
MNM3 net23 S net15 VPW nm1p2_svt_lp W=180e-9 L=60e-9 MR=1
MNM2 net23 SN net17 VPW nm1p2_svt_lp W=180e-9 L=60e-9 MR=1
MNM1 net15 B VSS VPW nm1p2_svt_lp W=180e-9 L=60e-9 MR=1
MNM0 net17 A VSS VPW nm1p2_svt_lp W=180e-9 L=60e-9 MR=1
MPM5 SN S VDD VNW pm1p2_svt_lp W=300e-9 L=60e-9 MR=1
MPM4 Y net23 VDD VNW pm1p2_svt_lp W=300e-9 L=60e-9 MR=1
MPM3 net23 SN net15 VNW pm1p2_svt_lp W=300e-9 L=60e-9 MR=1
MPM2 net23 S net17 VNW pm1p2_svt_lp W=300e-9 L=60e-9 MR=1
MPM1 net15 B VDD VNW pm1p2_svt_lp W=300e-9 L=60e-9 MR=1
MPM0 net17 A VDD VNW pm1p2_svt_lp W=300e-9 L=60e-9 MR=1
.ENDS
.SUBCKT CLKMX2X1_9TSVT A B S VDD VSS Y VNW VPW
MNM5 SN S VSS VPW nm1p2_svt_lp W=180e-9 L=60e-9 MR=1
MNM4 Y net23 VSS VPW nm1p2_svt_lp W=350e-9 L=60e-9 MR=1
MNM3 net23 S net15 VPW nm1p2_svt_lp W=350e-9 L=60e-9 MR=1
MNM2 net23 SN net17 VPW nm1p2_svt_lp W=350e-9 L=60e-9 MR=1
MNM1 net15 B VSS VPW nm1p2_svt_lp W=350e-9 L=60e-9 MR=1
MNM0 net17 A VSS VPW nm1p2_svt_lp W=350e-9 L=60e-9 MR=1
MPM5 SN S VDD VNW pm1p2_svt_lp W=300e-9 L=60e-9 MR=1
MPM4 Y net23 VDD VNW pm1p2_svt_lp W=590e-9 L=60e-9 MR=1
MPM3 net23 SN net15 VNW pm1p2_svt_lp W=590e-9 L=60e-9 MR=1
MPM2 net23 S net17 VNW pm1p2_svt_lp W=590e-9 L=60e-9 MR=1
MPM1 net15 B VDD VNW pm1p2_svt_lp W=590e-9 L=60e-9 MR=1
MPM0 net17 A VDD VNW pm1p2_svt_lp W=590e-9 L=60e-9 MR=1
.ENDS
.SUBCKT CLKMX2X2_9TSVT A B S VDD VSS Y VNW VPW
MNM5 SN S VSS VPW nm1p2_svt_lp W=180e-9 L=60e-9 MR=1
MNM4 Y net23 VSS VPW nm1p2_svt_lp W=700e-9 L=60e-9 MR=1
MNM3 net23 S net15 VPW nm1p2_svt_lp W=350e-9 L=60e-9 MR=1
MNM2 net23 SN net17 VPW nm1p2_svt_lp W=350e-9 L=60e-9 MR=1
MNM1 net15 B VSS VPW nm1p2_svt_lp W=350e-9 L=60e-9 MR=1
MNM0 net17 A VSS VPW nm1p2_svt_lp W=350e-9 L=60e-9 MR=1
MPM5 SN S VDD VNW pm1p2_svt_lp W=300e-9 L=60e-9 MR=1
MPM4 Y net23 VDD VNW pm1p2_svt_lp W=1.18e-6 L=60e-9 MR=1
MPM3 net23 SN net15 VNW pm1p2_svt_lp W=590e-9 L=60e-9 MR=1
MPM2 net23 S net17 VNW pm1p2_svt_lp W=590e-9 L=60e-9 MR=1
MPM1 net15 B VDD VNW pm1p2_svt_lp W=590e-9 L=60e-9 MR=1
MPM0 net17 A VDD VNW pm1p2_svt_lp W=590e-9 L=60e-9 MR=1
.ENDS
.SUBCKT CLKMX2X3_9TSVT A B S VDD VSS Y VNW VPW
MNM5 SN S VSS VPW nm1p2_svt_lp W=180e-9 L=60e-9 MR=1
MNM4 Y net23 VSS VPW nm1p2_svt_lp W=1.05e-6 L=60e-9 MR=1
MNM3 net23 S net15 VPW nm1p2_svt_lp W=350e-9 L=60e-9 MR=1
MNM2 net23 SN net17 VPW nm1p2_svt_lp W=350e-9 L=60e-9 MR=1
MNM1 net15 B VSS VPW nm1p2_svt_lp W=350e-9 L=60e-9 MR=1
MNM0 net17 A VSS VPW nm1p2_svt_lp W=350e-9 L=60e-9 MR=1
MPM5 SN S VDD VNW pm1p2_svt_lp W=300e-9 L=60e-9 MR=1
MPM4 Y net23 VDD VNW pm1p2_svt_lp W=1.77e-6 L=60e-9 MR=1
MPM3 net23 SN net15 VNW pm1p2_svt_lp W=590e-9 L=60e-9 MR=1
MPM2 net23 S net17 VNW pm1p2_svt_lp W=590e-9 L=60e-9 MR=1
MPM1 net15 B VDD VNW pm1p2_svt_lp W=590e-9 L=60e-9 MR=1
MPM0 net17 A VDD VNW pm1p2_svt_lp W=590e-9 L=60e-9 MR=1
.ENDS
.SUBCKT CLKMX2X4_9TSVT A B S VDD VSS Y VNW VPW
MNM5 SN S VSS VPW nm1p2_svt_lp W=180e-9 L=60e-9 MR=1
MNM4 Y net23 VSS VPW nm1p2_svt_lp W=1.4e-6 L=60e-9 MR=1
MNM3 net23 S net15 VPW nm1p2_svt_lp W=350e-9 L=60e-9 MR=1
MNM2 net23 SN net17 VPW nm1p2_svt_lp W=350e-9 L=60e-9 MR=1
MNM1 net15 B VSS VPW nm1p2_svt_lp W=700e-9 L=60e-9 MR=1
MNM0 net17 A VSS VPW nm1p2_svt_lp W=700e-9 L=60e-9 MR=1
MPM5 SN S VDD VNW pm1p2_svt_lp W=300e-9 L=60e-9 MR=1
MPM4 Y net23 VDD VNW pm1p2_svt_lp W=2.36e-6 L=60e-9 MR=1
MPM3 net23 SN net15 VNW pm1p2_svt_lp W=590e-9 L=60e-9 MR=1
MPM2 net23 S net17 VNW pm1p2_svt_lp W=590e-9 L=60e-9 MR=1
MPM1 net15 B VDD VNW pm1p2_svt_lp W=1.18e-6 L=60e-9 MR=1
MPM0 net17 A VDD VNW pm1p2_svt_lp W=1.18e-6 L=60e-9 MR=1
.ENDS
.SUBCKT CLKMX2X6_9TSVT A B S VDD VSS Y VNW VPW
MNM5 SN S VSS VPW nm1p2_svt_lp W=350e-9 L=60e-9 MR=1
MNM4 Y net23 VSS VPW nm1p2_svt_lp W=2.1e-6 L=60e-9 MR=1
MNM3 net23 S net15 VPW nm1p2_svt_lp W=350e-9 L=60e-9 MR=1
MNM2 net23 SN net17 VPW nm1p2_svt_lp W=350e-9 L=60e-9 MR=1
MNM1 net15 B VSS VPW nm1p2_svt_lp W=700e-9 L=60e-9 MR=1
MNM0 net17 A VSS VPW nm1p2_svt_lp W=700e-9 L=60e-9 MR=1
MPM5 SN S VDD VNW pm1p2_svt_lp W=590e-9 L=60e-9 MR=1
MPM4 Y net23 VDD VNW pm1p2_svt_lp W=3.54e-6 L=60e-9 MR=1
MPM3 net23 SN net15 VNW pm1p2_svt_lp W=590e-9 L=60e-9 MR=1
MPM2 net23 S net17 VNW pm1p2_svt_lp W=590e-9 L=60e-9 MR=1
MPM1 net15 B VDD VNW pm1p2_svt_lp W=1.18e-6 L=60e-9 MR=1
MPM0 net17 A VDD VNW pm1p2_svt_lp W=1.18e-6 L=60e-9 MR=1
.ENDS
.SUBCKT CLKMX2X8_9TSVT A B S VDD VSS Y VNW VPW
MNM5 SN S VSS VPW nm1p2_svt_lp W=350e-9 L=60e-9 MR=1
MNM4 Y net23 VSS VPW nm1p2_svt_lp W=2.8e-6 L=60e-9 MR=1
MNM3 net23 S net15 VPW nm1p2_svt_lp W=350e-9 L=60e-9 MR=1
MNM2 net23 SN net17 VPW nm1p2_svt_lp W=350e-9 L=60e-9 MR=1
MNM1 net15 B VSS VPW nm1p2_svt_lp W=1.05e-6 L=60e-9 MR=1
MNM0 net17 A VSS VPW nm1p2_svt_lp W=1.05e-6 L=60e-9 MR=1
MPM5 SN S VDD VNW pm1p2_svt_lp W=590e-9 L=60e-9 MR=1
MPM4 Y net23 VDD VNW pm1p2_svt_lp W=4.72e-6 L=60e-9 MR=1
MPM3 net23 SN net15 VNW pm1p2_svt_lp W=590e-9 L=60e-9 MR=1
MPM2 net23 S net17 VNW pm1p2_svt_lp W=590e-9 L=60e-9 MR=1
MPM1 net15 B VDD VNW pm1p2_svt_lp W=1.77e-6 L=60e-9 MR=1
MPM0 net17 A VDD VNW pm1p2_svt_lp W=1.77e-6 L=60e-9 MR=1
.ENDS
.SUBCKT CLKNAND2X0P5_9TSVT A B VDD VSS Y VNW VPW
MNM1 net15 B VSS VPW nm1p2_svt_lp W=210e-9 L=60e-9 MR=1
MNM0 Y A net15 VPW nm1p2_svt_lp W=210e-9 L=60e-9 MR=1
MPM1 Y B VDD VNW pm1p2_svt_lp W=300e-9 L=60e-9 MR=1
MPM0 Y A VDD VNW pm1p2_svt_lp W=300e-9 L=60e-9 MR=1
.ENDS
.SUBCKT CLKNAND2X1_9TSVT A B VDD VSS Y VNW VPW
MNM1 net15 B VSS VPW nm1p2_svt_lp W=410e-9 L=60e-9 MR=1
MNM0 Y A net15 VPW nm1p2_svt_lp W=410e-9 L=60e-9 MR=1
MPM1 Y B VDD VNW pm1p2_svt_lp W=590e-9 L=60e-9 MR=1
MPM0 Y A VDD VNW pm1p2_svt_lp W=590e-9 L=60e-9 MR=1
.ENDS
.SUBCKT CLKNAND2X2_9TSVT A B VDD VSS Y VNW VPW
MNM1 net15 B VSS VPW nm1p2_svt_lp W=820e-9 L=60e-9 MR=1
MNM0 Y A net15 VPW nm1p2_svt_lp W=820e-9 L=60e-9 MR=1
MPM1 Y B VDD VNW pm1p2_svt_lp W=1.18e-6 L=60e-9 MR=1
MPM0 Y A VDD VNW pm1p2_svt_lp W=1.18e-6 L=60e-9 MR=1
.ENDS
.SUBCKT CLKNAND2X3_9TSVT A B VDD VSS Y VNW VPW
MNM1 net15 B VSS VPW nm1p2_svt_lp W=1.23e-6 L=60e-9 MR=1
MNM0 Y A net15 VPW nm1p2_svt_lp W=1.23e-6 L=60e-9 MR=1
MPM1 Y B VDD VNW pm1p2_svt_lp W=1.77e-6 L=60e-9 MR=1
MPM0 Y A VDD VNW pm1p2_svt_lp W=1.77e-6 L=60e-9 MR=1
.ENDS
.SUBCKT CLKNAND2X4_9TSVT A B VDD VSS Y VNW VPW
MNM1 net15 B VSS VPW nm1p2_svt_lp W=1.64e-6 L=60e-9 MR=1
MNM0 Y A net15 VPW nm1p2_svt_lp W=1.64e-6 L=60e-9 MR=1
MPM1 Y B VDD VNW pm1p2_svt_lp W=2.36e-6 L=60e-9 MR=1
MPM0 Y A VDD VNW pm1p2_svt_lp W=2.36e-6 L=60e-9 MR=1
.ENDS
.SUBCKT CLKNAND2X6_9TSVT A B VDD VSS Y VNW VPW
MNM1 net15 B VSS VPW nm1p2_svt_lp W=2.46e-6 L=60e-9 MR=1
MNM0 Y A net15 VPW nm1p2_svt_lp W=2.46e-6 L=60e-9 MR=1
MPM1 Y B VDD VNW pm1p2_svt_lp W=3.54e-6 L=60e-9 MR=1
MPM0 Y A VDD VNW pm1p2_svt_lp W=3.54e-6 L=60e-9 MR=1
.ENDS
.SUBCKT CLKNAND2X8_9TSVT A B VDD VSS Y VNW VPW
MNM1 net15 B VSS VPW nm1p2_svt_lp W=3.28e-6 L=60e-9 MR=1
MNM0 Y A net15 VPW nm1p2_svt_lp W=3.28e-6 L=60e-9 MR=1
MPM1 Y B VDD VNW pm1p2_svt_lp W=4.72e-6 L=60e-9 MR=1
MPM0 Y A VDD VNW pm1p2_svt_lp W=4.72e-6 L=60e-9 MR=1
.ENDS
.SUBCKT CLKXOR2X0P5_9TSVT A B VDD VSS Y VNW VPW
MNM5 Y net16 VSS VPW nm1p2_svt_lp W=180e-9 L=60e-9 MR=1
MNM4 net16 AN BN VPW nm1p2_svt_lp W=180e-9 L=60e-9 MR=1
MNM3 net16 A BB VPW nm1p2_svt_lp W=180e-9 L=60e-9 MR=1
MNM2 BB BN VSS VPW nm1p2_svt_lp W=180e-9 L=60e-9 MR=1
MNM1 BN B VSS VPW nm1p2_svt_lp W=180e-9 L=60e-9 MR=1
MNM0 AN A VSS VPW nm1p2_svt_lp W=180e-9 L=60e-9 MR=1
MPM5 Y net16 VDD VNW pm1p2_svt_lp W=300e-9 L=60e-9 MR=1
MPM4 net16 A BN VNW pm1p2_svt_lp W=300e-9 L=60e-9 MR=1
MPM3 net16 AN BB VNW pm1p2_svt_lp W=300e-9 L=60e-9 MR=1
MPM2 BB BN VDD VNW pm1p2_svt_lp W=300e-9 L=60e-9 MR=1
MPM1 BN B VDD VNW pm1p2_svt_lp W=300e-9 L=60e-9 MR=1
MPM0 AN A VDD VNW pm1p2_svt_lp W=300e-9 L=60e-9 MR=1
.ENDS
.SUBCKT CLKXOR2X1_9TSVT A B VDD VSS Y VNW VPW
MNM5 Y net16 VSS VPW nm1p2_svt_lp W=350e-9 L=60e-9 MR=1
MNM4 net16 AN BN VPW nm1p2_svt_lp W=180e-9 L=60e-9 MR=1
MNM3 net16 A BB VPW nm1p2_svt_lp W=180e-9 L=60e-9 MR=1
MNM2 BB BN VSS VPW nm1p2_svt_lp W=180e-9 L=60e-9 MR=1
MNM1 BN B VSS VPW nm1p2_svt_lp W=180e-9 L=60e-9 MR=1
MNM0 AN A VSS VPW nm1p2_svt_lp W=180e-9 L=60e-9 MR=1
MPM5 Y net16 VDD VNW pm1p2_svt_lp W=590e-9 L=60e-9 MR=1
MPM4 net16 A BN VNW pm1p2_svt_lp W=300e-9 L=60e-9 MR=1
MPM3 net16 AN BB VNW pm1p2_svt_lp W=300e-9 L=60e-9 MR=1
MPM2 BB BN VDD VNW pm1p2_svt_lp W=300e-9 L=60e-9 MR=1
MPM1 BN B VDD VNW pm1p2_svt_lp W=300e-9 L=60e-9 MR=1
MPM0 AN A VDD VNW pm1p2_svt_lp W=300e-9 L=60e-9 MR=1
.ENDS
.SUBCKT CLKXOR2X2_9TSVT A B VDD VSS Y VNW VPW
MNM5 Y net16 VSS VPW nm1p2_svt_lp W=700e-9 L=60e-9 MR=1
MNM4 net16 AN BN VPW nm1p2_svt_lp W=350e-9 L=60e-9 MR=1
MNM3 net16 A BB VPW nm1p2_svt_lp W=350e-9 L=60e-9 MR=1
MNM2 BB BN VSS VPW nm1p2_svt_lp W=350e-9 L=60e-9 MR=1
MNM1 BN B VSS VPW nm1p2_svt_lp W=350e-9 L=60e-9 MR=1
MNM0 AN A VSS VPW nm1p2_svt_lp W=180e-9 L=60e-9 MR=1
MPM5 Y net16 VDD VNW pm1p2_svt_lp W=1.18e-6 L=60e-9 MR=1
MPM4 net16 A BN VNW pm1p2_svt_lp W=590e-9 L=60e-9 MR=1
MPM3 net16 AN BB VNW pm1p2_svt_lp W=590e-9 L=60e-9 MR=1
MPM2 BB BN VDD VNW pm1p2_svt_lp W=590e-9 L=60e-9 MR=1
MPM1 BN B VDD VNW pm1p2_svt_lp W=590e-9 L=60e-9 MR=1
MPM0 AN A VDD VNW pm1p2_svt_lp W=300e-9 L=60e-9 MR=1
.ENDS
.SUBCKT CLKXOR2X4_9TSVT A B VDD VSS Y VNW VPW
MNM5 Y net16 VSS VPW nm1p2_svt_lp W=1.4e-6 L=60e-9 MR=1
MNM4 net16 AN BN VPW nm1p2_svt_lp W=350e-9 L=60e-9 MR=1
MNM3 net16 A BB VPW nm1p2_svt_lp W=350e-9 L=60e-9 MR=1
MNM2 BB BN VSS VPW nm1p2_svt_lp W=350e-9 L=60e-9 MR=1
MNM1 BN B VSS VPW nm1p2_svt_lp W=700e-9 L=60e-9 MR=1
MNM0 AN A VSS VPW nm1p2_svt_lp W=350e-9 L=60e-9 MR=1
MPM5 Y net16 VDD VNW pm1p2_svt_lp W=2.36e-6 L=60e-9 MR=1
MPM4 net16 A BN VNW pm1p2_svt_lp W=590e-9 L=60e-9 MR=1
MPM3 net16 AN BB VNW pm1p2_svt_lp W=590e-9 L=60e-9 MR=1
MPM2 BB BN VDD VNW pm1p2_svt_lp W=590e-9 L=60e-9 MR=1
MPM1 BN B VDD VNW pm1p2_svt_lp W=1.18e-6 L=60e-9 MR=1
MPM0 AN A VDD VNW pm1p2_svt_lp W=590e-9 L=60e-9 MR=1
.ENDS
.SUBCKT CLKXOR2X8_9TSVT A B VDD VSS Y VNW VPW
MNM5 Y net16 VSS VPW nm1p2_svt_lp W=2.8e-6 L=60e-9 MR=1
MNM4 net16 AN BN VPW nm1p2_svt_lp W=350e-9 L=60e-9 MR=1
MNM3 net16 A BB VPW nm1p2_svt_lp W=350e-9 L=60e-9 MR=1
MNM2 BB BN VSS VPW nm1p2_svt_lp W=350e-9 L=60e-9 MR=1
MNM1 BN B VSS VPW nm1p2_svt_lp W=1.05e-6 L=60e-9 MR=1
MNM0 AN A VSS VPW nm1p2_svt_lp W=350e-9 L=60e-9 MR=1
MPM5 Y net16 VDD VNW pm1p2_svt_lp W=4.72e-6 L=60e-9 MR=1
MPM4 net16 A BN VNW pm1p2_svt_lp W=590e-9 L=60e-9 MR=1
MPM3 net16 AN BB VNW pm1p2_svt_lp W=590e-9 L=60e-9 MR=1
MPM2 BB BN VDD VNW pm1p2_svt_lp W=590e-9 L=60e-9 MR=1
MPM1 BN B VDD VNW pm1p2_svt_lp W=1.77e-6 L=60e-9 MR=1
MPM0 AN A VDD VNW pm1p2_svt_lp W=590e-9 L=60e-9 MR=1
.ENDS
.SUBCKT CMPR42X1_9TSVT A B C CO D ICI ICO SUM VDD VSS VNW VPW
MNM27 SUM nsum VSS VPW nm1p2_svt_lp W=470e-9 L=60e-9 MR=1
MNM26 nsum S net74 VPW nm1p2_svt_lp W=470e-9 L=60e-9 MR=1
MNM25 net74 ICI net75 VPW nm1p2_svt_lp W=470e-9 L=60e-9 MR=1
MNM24 net75 D VSS VPW nm1p2_svt_lp W=470e-9 L=60e-9 MR=1
MNM23 net70 D VSS VPW nm1p2_svt_lp W=470e-9 L=60e-9 MR=1
MNM22 nsum nco net70 VPW nm1p2_svt_lp W=470e-9 L=60e-9 MR=1
MNM21 net70 ICI VSS VPW nm1p2_svt_lp W=470e-9 L=60e-9 MR=1
MNM20 net70 S VSS VPW nm1p2_svt_lp W=470e-9 L=60e-9 MR=1
MNM19 CO nco VSS VPW nm1p2_svt_lp W=470e-9 L=60e-9 MR=1
MNM18 nco ICI net77 VPW nm1p2_svt_lp W=470e-9 L=60e-9 MR=1
MNM17 net77 D VSS VPW nm1p2_svt_lp W=470e-9 L=60e-9 MR=1
MNM16 nco S net67 VPW nm1p2_svt_lp W=250e-9 L=60e-9 MR=1
MNM15 net67 ICI VSS VPW nm1p2_svt_lp W=470e-9 L=60e-9 MR=1
MNM14 net67 D VSS VPW nm1p2_svt_lp W=470e-9 L=60e-9 MR=1
MNM13 S ns VSS VPW nm1p2_svt_lp W=470e-9 L=60e-9 MR=1
MNM12 ns C net80 VPW nm1p2_svt_lp W=470e-9 L=60e-9 MR=1
MNM11 net80 A net81 VPW nm1p2_svt_lp W=470e-9 L=60e-9 MR=1
MNM10 net81 B VSS VPW nm1p2_svt_lp W=470e-9 L=60e-9 MR=1
MNM9 net65 C VSS VPW nm1p2_svt_lp W=470e-9 L=60e-9 MR=1
MNM8 ns nico net65 VPW nm1p2_svt_lp W=470e-9 L=60e-9 MR=1
MNM7 net65 B VSS VPW nm1p2_svt_lp W=470e-9 L=60e-9 MR=1
MNM6 net65 A VSS VPW nm1p2_svt_lp W=470e-9 L=60e-9 MR=1
MNM5 ICO nico VSS VPW nm1p2_svt_lp W=470e-9 L=60e-9 MR=1
MNM4 nico A net83 VPW nm1p2_svt_lp W=470e-9 L=60e-9 MR=1
MNM3 net83 B VSS VPW nm1p2_svt_lp W=470e-9 L=60e-9 MR=1
MNM2 nico C net61 VPW nm1p2_svt_lp W=470e-9 L=60e-9 MR=1
MNM1 net61 B VSS VPW nm1p2_svt_lp W=470e-9 L=60e-9 MR=1
MNM0 net61 A VSS VPW nm1p2_svt_lp W=470e-9 L=60e-9 MR=1
MPM27 SUM nsum VDD VNW pm1p2_svt_lp W=590e-9 L=60e-9 MR=1
MPM24 net72 D VDD VNW pm1p2_svt_lp W=590e-9 L=60e-9 MR=1
MPM25 net73 ICI net72 VNW pm1p2_svt_lp W=590e-9 L=60e-9 MR=1
MPM26 nsum S net73 VNW pm1p2_svt_lp W=590e-9 L=60e-9 MR=1
MPM23 net71 D VDD VNW pm1p2_svt_lp W=390e-9 L=60e-9 MR=1
MPM21 net71 ICI VDD VNW pm1p2_svt_lp W=390e-9 L=60e-9 MR=1
MPM22 nsum nco net71 VNW pm1p2_svt_lp W=390e-9 L=60e-9 MR=1
MPM20 net71 S VDD VNW pm1p2_svt_lp W=590e-9 L=60e-9 MR=1
MPM19 CO nco VDD VNW pm1p2_svt_lp W=590e-9 L=60e-9 MR=1
MPM17 net76 D VDD VNW pm1p2_svt_lp W=590e-9 L=60e-9 MR=1
MPM18 nco ICI net76 VNW pm1p2_svt_lp W=590e-9 L=60e-9 MR=1
MPM15 net68 ICI VDD VNW pm1p2_svt_lp W=390e-9 L=60e-9 MR=1
MPM16 nco S net68 VNW pm1p2_svt_lp W=590e-9 L=60e-9 MR=1
MPM14 net68 D VDD VNW pm1p2_svt_lp W=390e-9 L=60e-9 MR=1
MPM13 S ns VDD VNW pm1p2_svt_lp W=590e-9 L=60e-9 MR=1
MPM10 net78 B VDD VNW pm1p2_svt_lp W=590e-9 L=60e-9 MR=1
MPM11 net79 A net78 VNW pm1p2_svt_lp W=590e-9 L=60e-9 MR=1
MPM12 ns C net79 VNW pm1p2_svt_lp W=590e-9 L=60e-9 MR=1
MPM9 net66 C VDD VNW pm1p2_svt_lp W=590e-9 L=60e-9 MR=1
MPM7 net66 B VDD VNW pm1p2_svt_lp W=390e-9 L=60e-9 MR=1
MPM8 ns nico net66 VNW pm1p2_svt_lp W=390e-9 L=60e-9 MR=1
MPM6 net66 A VDD VNW pm1p2_svt_lp W=390e-9 L=60e-9 MR=1
MPM5 ICO nico VDD VNW pm1p2_svt_lp W=590e-9 L=60e-9 MR=1
MPM3 net82 B VDD VNW pm1p2_svt_lp W=590e-9 L=60e-9 MR=1
MPM4 nico A net82 VNW pm1p2_svt_lp W=590e-9 L=60e-9 MR=1
MPM1 net62 B VDD VNW pm1p2_svt_lp W=390e-9 L=60e-9 MR=1
MPM2 nico C net62 VNW pm1p2_svt_lp W=590e-9 L=60e-9 MR=1
MPM0 net62 A VDD VNW pm1p2_svt_lp W=390e-9 L=60e-9 MR=1
.ENDS
.SUBCKT CMPR42X2_9TSVT A B C CO D ICI ICO SUM VDD VSS VNW VPW
MNM27 SUM nsum VSS VPW nm1p2_svt_lp W=940e-9 L=60e-9 MR=1
MNM26 nsum S net74 VPW nm1p2_svt_lp W=470e-9 L=60e-9 MR=1
MNM25 net74 ICI net75 VPW nm1p2_svt_lp W=470e-9 L=60e-9 MR=1
MNM24 net75 D VSS VPW nm1p2_svt_lp W=470e-9 L=60e-9 MR=1
MNM23 net70 D VSS VPW nm1p2_svt_lp W=470e-9 L=60e-9 MR=1
MNM22 nsum nco net70 VPW nm1p2_svt_lp W=470e-9 L=60e-9 MR=1
MNM21 net70 ICI VSS VPW nm1p2_svt_lp W=470e-9 L=60e-9 MR=1
MNM20 net70 S VSS VPW nm1p2_svt_lp W=470e-9 L=60e-9 MR=1
MNM19 CO nco VSS VPW nm1p2_svt_lp W=940e-9 L=60e-9 MR=1
MNM18 nco ICI net77 VPW nm1p2_svt_lp W=470e-9 L=60e-9 MR=1
MNM17 net77 D VSS VPW nm1p2_svt_lp W=470e-9 L=60e-9 MR=1
MNM16 nco S net67 VPW nm1p2_svt_lp W=250e-9 L=60e-9 MR=1
MNM15 net67 ICI VSS VPW nm1p2_svt_lp W=470e-9 L=60e-9 MR=1
MNM14 net67 D VSS VPW nm1p2_svt_lp W=470e-9 L=60e-9 MR=1
MNM13 S ns VSS VPW nm1p2_svt_lp W=470e-9 L=60e-9 MR=1
MNM12 ns C net80 VPW nm1p2_svt_lp W=470e-9 L=60e-9 MR=1
MNM11 net80 A net81 VPW nm1p2_svt_lp W=470e-9 L=60e-9 MR=1
MNM10 net81 B VSS VPW nm1p2_svt_lp W=470e-9 L=60e-9 MR=1
MNM9 net65 C VSS VPW nm1p2_svt_lp W=470e-9 L=60e-9 MR=1
MNM8 ns nico net65 VPW nm1p2_svt_lp W=470e-9 L=60e-9 MR=1
MNM7 net65 B VSS VPW nm1p2_svt_lp W=470e-9 L=60e-9 MR=1
MNM6 net65 A VSS VPW nm1p2_svt_lp W=470e-9 L=60e-9 MR=1
MNM5 ICO nico VSS VPW nm1p2_svt_lp W=940e-9 L=60e-9 MR=1
MNM4 nico A net83 VPW nm1p2_svt_lp W=470e-9 L=60e-9 MR=1
MNM3 net83 B VSS VPW nm1p2_svt_lp W=470e-9 L=60e-9 MR=1
MNM2 nico C net61 VPW nm1p2_svt_lp W=470e-9 L=60e-9 MR=1
MNM1 net61 B VSS VPW nm1p2_svt_lp W=470e-9 L=60e-9 MR=1
MNM0 net61 A VSS VPW nm1p2_svt_lp W=470e-9 L=60e-9 MR=1
MPM27 SUM nsum VDD VNW pm1p2_svt_lp W=1.18e-6 L=60e-9 MR=1
MPM24 net72 D VDD VNW pm1p2_svt_lp W=590e-9 L=60e-9 MR=1
MPM25 net73 ICI net72 VNW pm1p2_svt_lp W=590e-9 L=60e-9 MR=1
MPM26 nsum S net73 VNW pm1p2_svt_lp W=590e-9 L=60e-9 MR=1
MPM23 net71 D VDD VNW pm1p2_svt_lp W=390e-9 L=60e-9 MR=1
MPM21 net71 ICI VDD VNW pm1p2_svt_lp W=390e-9 L=60e-9 MR=1
MPM22 nsum nco net71 VNW pm1p2_svt_lp W=390e-9 L=60e-9 MR=1
MPM20 net71 S VDD VNW pm1p2_svt_lp W=590e-9 L=60e-9 MR=1
MPM19 CO nco VDD VNW pm1p2_svt_lp W=1.18e-6 L=60e-9 MR=1
MPM17 net76 D VDD VNW pm1p2_svt_lp W=590e-9 L=60e-9 MR=1
MPM18 nco ICI net76 VNW pm1p2_svt_lp W=590e-9 L=60e-9 MR=1
MPM15 net68 ICI VDD VNW pm1p2_svt_lp W=390e-9 L=60e-9 MR=1
MPM16 nco S net68 VNW pm1p2_svt_lp W=590e-9 L=60e-9 MR=1
MPM14 net68 D VDD VNW pm1p2_svt_lp W=390e-9 L=60e-9 MR=1
MPM13 S ns VDD VNW pm1p2_svt_lp W=590e-9 L=60e-9 MR=1
MPM10 net78 B VDD VNW pm1p2_svt_lp W=590e-9 L=60e-9 MR=1
MPM11 net79 A net78 VNW pm1p2_svt_lp W=590e-9 L=60e-9 MR=1
MPM12 ns C net79 VNW pm1p2_svt_lp W=590e-9 L=60e-9 MR=1
MPM9 net66 C VDD VNW pm1p2_svt_lp W=590e-9 L=60e-9 MR=1
MPM7 net66 B VDD VNW pm1p2_svt_lp W=390e-9 L=60e-9 MR=1
MPM8 ns nico net66 VNW pm1p2_svt_lp W=390e-9 L=60e-9 MR=1
MPM6 net66 A VDD VNW pm1p2_svt_lp W=390e-9 L=60e-9 MR=1
MPM5 ICO nico VDD VNW pm1p2_svt_lp W=1.18e-6 L=60e-9 MR=1
MPM3 net82 B VDD VNW pm1p2_svt_lp W=590e-9 L=60e-9 MR=1
MPM4 nico A net82 VNW pm1p2_svt_lp W=590e-9 L=60e-9 MR=1
MPM1 net62 B VDD VNW pm1p2_svt_lp W=390e-9 L=60e-9 MR=1
MPM2 nico C net62 VNW pm1p2_svt_lp W=590e-9 L=60e-9 MR=1
MPM0 net62 A VDD VNW pm1p2_svt_lp W=390e-9 L=60e-9 MR=1
.ENDS
.SUBCKT DEL2X0P5_9TSVT A VDD VSS Y VNW VPW
MNM5 Y net15 VSS VPW nm1p2_svt_lp W=230e-9 L=60e-9 MR=1
MNM4 net9 A VSS VPW nm1p2_svt_lp W=230e-9 L=60e-9 MR=1
MNM3 net15 net12 net20 VPW nm1p2_svt_lp W=230e-9 L=60e-9 MR=1
MNM2 net20 net12 VSS VPW nm1p2_svt_lp W=230e-9 L=60e-9 MR=1
MNM1 net12 net9 net22 VPW nm1p2_svt_lp W=230e-9 L=60e-9 MR=1
MNM0 net22 net9 VSS VPW nm1p2_svt_lp W=230e-9 L=60e-9 MR=1
MPM5 Y net15 VDD VNW pm1p2_svt_lp W=300e-9 L=60e-9 MR=1
MPM4 net9 A VDD VNW pm1p2_svt_lp W=300e-9 L=60e-9 MR=1
MPM2 net19 net12 VDD VNW pm1p2_svt_lp W=300e-9 L=60e-9 MR=1
MPM3 net15 net12 net19 VNW pm1p2_svt_lp W=300e-9 L=60e-9 MR=1
MPM0 net21 net9 VDD VNW pm1p2_svt_lp W=300e-9 L=60e-9 MR=1
MPM1 net12 net9 net21 VNW pm1p2_svt_lp W=300e-9 L=60e-9 MR=1
.ENDS
.SUBCKT DEL2X1_9TSVT A VDD VSS Y VNW VPW
MNM5 Y net15 VSS VPW nm1p2_svt_lp W=470e-9 L=60e-9 MR=1
MNM4 net9 A VSS VPW nm1p2_svt_lp W=470e-9 L=60e-9 MR=1
MNM3 net15 net12 net20 VPW nm1p2_svt_lp W=470e-9 L=60e-9 MR=1
MNM2 net20 net12 VSS VPW nm1p2_svt_lp W=470e-9 L=60e-9 MR=1
MNM1 net12 net9 net22 VPW nm1p2_svt_lp W=470e-9 L=60e-9 MR=1
MNM0 net22 net9 VSS VPW nm1p2_svt_lp W=470e-9 L=60e-9 MR=1
MPM5 Y net15 VDD VNW pm1p2_svt_lp W=590e-9 L=60e-9 MR=1
MPM4 net9 A VDD VNW pm1p2_svt_lp W=590e-9 L=60e-9 MR=1
MPM2 net19 net12 VDD VNW pm1p2_svt_lp W=590e-9 L=60e-9 MR=1
MPM3 net15 net12 net19 VNW pm1p2_svt_lp W=590e-9 L=60e-9 MR=1
MPM0 net21 net9 VDD VNW pm1p2_svt_lp W=590e-9 L=60e-9 MR=1
MPM1 net12 net9 net21 VNW pm1p2_svt_lp W=590e-9 L=60e-9 MR=1
.ENDS
.SUBCKT DEL2X2_9TSVT A VDD VSS Y VNW VPW
MNM5 Y net15 VSS VPW nm1p2_svt_lp W=940e-9 L=60e-9 MR=1
MNM4 net9 A VSS VPW nm1p2_svt_lp W=470e-9 L=60e-9 MR=1
MNM3 net15 net12 net20 VPW nm1p2_svt_lp W=470e-9 L=60e-9 MR=1
MNM2 net20 net12 VSS VPW nm1p2_svt_lp W=470e-9 L=60e-9 MR=1
MNM1 net12 net9 net22 VPW nm1p2_svt_lp W=470e-9 L=60e-9 MR=1
MNM0 net22 net9 VSS VPW nm1p2_svt_lp W=470e-9 L=60e-9 MR=1
MPM5 Y net15 VDD VNW pm1p2_svt_lp W=1.18e-6 L=60e-9 MR=1
MPM4 net9 A VDD VNW pm1p2_svt_lp W=590e-9 L=60e-9 MR=1
MPM2 net19 net12 VDD VNW pm1p2_svt_lp W=590e-9 L=60e-9 MR=1
MPM3 net15 net12 net19 VNW pm1p2_svt_lp W=590e-9 L=60e-9 MR=1
MPM0 net21 net9 VDD VNW pm1p2_svt_lp W=590e-9 L=60e-9 MR=1
MPM1 net12 net9 net21 VNW pm1p2_svt_lp W=590e-9 L=60e-9 MR=1
.ENDS
.SUBCKT DEL2X4_9TSVT A VDD VSS Y VNW VPW
MNM5 Y net15 VSS VPW nm1p2_svt_lp W=1.88e-6 L=60e-9 MR=1
MNM4 net9 A VSS VPW nm1p2_svt_lp W=470n L=60n MR=1
MNM3 net15 net12 net20 VPW nm1p2_svt_lp W=470e-9 L=60e-9 MR=1
MNM2 net20 net12 VSS VPW nm1p2_svt_lp W=470e-9 L=60e-9 MR=1
MNM1 net12 net9 net22 VPW nm1p2_svt_lp W=470e-9 L=60e-9 MR=1
MNM0 net22 net9 VSS VPW nm1p2_svt_lp W=470e-9 L=60e-9 MR=1
MPM5 Y net15 VDD VNW pm1p2_svt_lp W=2.36e-6 L=60e-9 MR=1
MPM4 net9 A VDD VNW pm1p2_svt_lp W=590n L=60n MR=1
MPM2 net19 net12 VDD VNW pm1p2_svt_lp W=590e-9 L=60e-9 MR=1
MPM3 net15 net12 net19 VNW pm1p2_svt_lp W=590e-9 L=60e-9 MR=1
MPM0 net21 net9 VDD VNW pm1p2_svt_lp W=590e-9 L=60e-9 MR=1
MPM1 net12 net9 net21 VNW pm1p2_svt_lp W=590e-9 L=60e-9 MR=1
.ENDS
.SUBCKT DEL4X0P5_9TSVT A VDD VSS Y VNW VPW
MNM9 Y net21 VSS VPW nm1p2_svt_lp W=230e-9 L=60e-9 MR=1
MNM8 net9 A VSS VPW nm1p2_svt_lp W=230e-9 L=60e-9 MR=1
MNM7 net21 net18 net26 VPW nm1p2_svt_lp W=230e-9 L=60e-9 MR=1
MNM6 net26 net18 VSS VPW nm1p2_svt_lp W=230e-9 L=60e-9 MR=1
MNM5 net18 net15 net28 VPW nm1p2_svt_lp W=230e-9 L=60e-9 MR=1
MNM4 net28 net15 VSS VPW nm1p2_svt_lp W=230e-9 L=60e-9 MR=1
MNM3 net15 net12 net30 VPW nm1p2_svt_lp W=230e-9 L=60e-9 MR=1
MNM2 net30 net12 VSS VPW nm1p2_svt_lp W=230e-9 L=60e-9 MR=1
MNM1 net12 net9 net32 VPW nm1p2_svt_lp W=230e-9 L=60e-9 MR=1
MNM0 net32 net9 VSS VPW nm1p2_svt_lp W=230e-9 L=60e-9 MR=1
MPM9 Y net21 VDD VNW pm1p2_svt_lp W=300e-9 L=60e-9 MR=1
MPM8 net9 A VDD VNW pm1p2_svt_lp W=300e-9 L=60e-9 MR=1
MPM6 net25 net18 VDD VNW pm1p2_svt_lp W=300e-9 L=60e-9 MR=1
MPM7 net21 net18 net25 VNW pm1p2_svt_lp W=300e-9 L=60e-9 MR=1
MPM4 net27 net15 VDD VNW pm1p2_svt_lp W=300e-9 L=60e-9 MR=1
MPM5 net18 net15 net27 VNW pm1p2_svt_lp W=300e-9 L=60e-9 MR=1
MPM2 net29 net12 VDD VNW pm1p2_svt_lp W=300e-9 L=60e-9 MR=1
MPM3 net15 net12 net29 VNW pm1p2_svt_lp W=300e-9 L=60e-9 MR=1
MPM0 net31 net9 VDD VNW pm1p2_svt_lp W=300e-9 L=60e-9 MR=1
MPM1 net12 net9 net31 VNW pm1p2_svt_lp W=300e-9 L=60e-9 MR=1
.ENDS
.SUBCKT DEL4X1_9TSVT A VDD VSS Y VNW VPW
MNM9 Y net21 VSS VPW nm1p2_svt_lp W=470e-9 L=60e-9 MR=1
MNM8 net9 A VSS VPW nm1p2_svt_lp W=470e-9 L=60e-9 MR=1
MNM7 net21 net18 net26 VPW nm1p2_svt_lp W=470e-9 L=60e-9 MR=1
MNM6 net26 net18 VSS VPW nm1p2_svt_lp W=470e-9 L=60e-9 MR=1
MNM5 net18 net15 net28 VPW nm1p2_svt_lp W=470e-9 L=60e-9 MR=1
MNM4 net28 net15 VSS VPW nm1p2_svt_lp W=470e-9 L=60e-9 MR=1
MNM3 net15 net12 net30 VPW nm1p2_svt_lp W=470e-9 L=60e-9 MR=1
MNM2 net30 net12 VSS VPW nm1p2_svt_lp W=470e-9 L=60e-9 MR=1
MNM1 net12 net9 net32 VPW nm1p2_svt_lp W=470e-9 L=60e-9 MR=1
MNM0 net32 net9 VSS VPW nm1p2_svt_lp W=470e-9 L=60e-9 MR=1
MPM9 Y net21 VDD VNW pm1p2_svt_lp W=590e-9 L=60e-9 MR=1
MPM8 net9 A VDD VNW pm1p2_svt_lp W=590e-9 L=60e-9 MR=1
MPM6 net25 net18 VDD VNW pm1p2_svt_lp W=590e-9 L=60e-9 MR=1
MPM7 net21 net18 net25 VNW pm1p2_svt_lp W=590e-9 L=60e-9 MR=1
MPM4 net27 net15 VDD VNW pm1p2_svt_lp W=590e-9 L=60e-9 MR=1
MPM5 net18 net15 net27 VNW pm1p2_svt_lp W=590e-9 L=60e-9 MR=1
MPM2 net29 net12 VDD VNW pm1p2_svt_lp W=590e-9 L=60e-9 MR=1
MPM3 net15 net12 net29 VNW pm1p2_svt_lp W=590e-9 L=60e-9 MR=1
MPM0 net31 net9 VDD VNW pm1p2_svt_lp W=590e-9 L=60e-9 MR=1
MPM1 net12 net9 net31 VNW pm1p2_svt_lp W=590e-9 L=60e-9 MR=1
.ENDS
.SUBCKT DEL4X2_9TSVT A VDD VSS Y VNW VPW
MNM9 Y net21 VSS VPW nm1p2_svt_lp W=940e-9 L=60e-9 MR=1
MNM8 net9 A VSS VPW nm1p2_svt_lp W=470e-9 L=60e-9 MR=1
MNM7 net21 net18 net26 VPW nm1p2_svt_lp W=470e-9 L=60e-9 MR=1
MNM6 net26 net18 VSS VPW nm1p2_svt_lp W=470e-9 L=60e-9 MR=1
MNM5 net18 net15 net28 VPW nm1p2_svt_lp W=470e-9 L=60e-9 MR=1
MNM4 net28 net15 VSS VPW nm1p2_svt_lp W=470e-9 L=60e-9 MR=1
MNM3 net15 net12 net30 VPW nm1p2_svt_lp W=470e-9 L=60e-9 MR=1
MNM2 net30 net12 VSS VPW nm1p2_svt_lp W=470e-9 L=60e-9 MR=1
MNM1 net12 net9 net32 VPW nm1p2_svt_lp W=470e-9 L=60e-9 MR=1
MNM0 net32 net9 VSS VPW nm1p2_svt_lp W=470e-9 L=60e-9 MR=1
MPM9 Y net21 VDD VNW pm1p2_svt_lp W=1.18e-6 L=60e-9 MR=1
MPM8 net9 A VDD VNW pm1p2_svt_lp W=590e-9 L=60e-9 MR=1
MPM6 net25 net18 VDD VNW pm1p2_svt_lp W=590e-9 L=60e-9 MR=1
MPM7 net21 net18 net25 VNW pm1p2_svt_lp W=590e-9 L=60e-9 MR=1
MPM4 net27 net15 VDD VNW pm1p2_svt_lp W=590e-9 L=60e-9 MR=1
MPM5 net18 net15 net27 VNW pm1p2_svt_lp W=590e-9 L=60e-9 MR=1
MPM2 net29 net12 VDD VNW pm1p2_svt_lp W=590e-9 L=60e-9 MR=1
MPM3 net15 net12 net29 VNW pm1p2_svt_lp W=590e-9 L=60e-9 MR=1
MPM0 net31 net9 VDD VNW pm1p2_svt_lp W=590e-9 L=60e-9 MR=1
MPM1 net12 net9 net31 VNW pm1p2_svt_lp W=590e-9 L=60e-9 MR=1
.ENDS
.SUBCKT DEL4X4_9TSVT A VDD VSS Y VNW VPW
MNM9 Y net21 VSS VPW nm1p2_svt_lp W=1.88e-6 L=60e-9 MR=1
MNM8 net9 A VSS VPW nm1p2_svt_lp W=470n L=60n MR=1
MNM7 net21 net18 net26 VPW nm1p2_svt_lp W=470e-9 L=60e-9 MR=1
MNM6 net26 net18 VSS VPW nm1p2_svt_lp W=470e-9 L=60e-9 MR=1
MNM5 net18 net15 net28 VPW nm1p2_svt_lp W=470e-9 L=60e-9 MR=1
MNM4 net28 net15 VSS VPW nm1p2_svt_lp W=470e-9 L=60e-9 MR=1
MNM3 net15 net12 net30 VPW nm1p2_svt_lp W=470e-9 L=60e-9 MR=1
MNM2 net30 net12 VSS VPW nm1p2_svt_lp W=470e-9 L=60e-9 MR=1
MNM1 net12 net9 net32 VPW nm1p2_svt_lp W=470e-9 L=60e-9 MR=1
MNM0 net32 net9 VSS VPW nm1p2_svt_lp W=470e-9 L=60e-9 MR=1
MPM9 Y net21 VDD VNW pm1p2_svt_lp W=2.36e-6 L=60e-9 MR=1
MPM8 net9 A VDD VNW pm1p2_svt_lp W=590n L=60n MR=1
MPM6 net25 net18 VDD VNW pm1p2_svt_lp W=590e-9 L=60e-9 MR=1
MPM7 net21 net18 net25 VNW pm1p2_svt_lp W=590e-9 L=60e-9 MR=1
MPM4 net27 net15 VDD VNW pm1p2_svt_lp W=590e-9 L=60e-9 MR=1
MPM5 net18 net15 net27 VNW pm1p2_svt_lp W=590e-9 L=60e-9 MR=1
MPM2 net29 net12 VDD VNW pm1p2_svt_lp W=590e-9 L=60e-9 MR=1
MPM3 net15 net12 net29 VNW pm1p2_svt_lp W=590e-9 L=60e-9 MR=1
MPM0 net31 net9 VDD VNW pm1p2_svt_lp W=590e-9 L=60e-9 MR=1
MPM1 net12 net9 net31 VNW pm1p2_svt_lp W=590e-9 L=60e-9 MR=1
.ENDS
.SUBCKT DFFKRNQX0P5_9TSVT CK D Q RN VDD VSS VNW VPW
MNM12 Q net35 VSS VPW nm1p2_svt_lp W=230e-9 L=60e-9 MR=1
MNM9 net41 net35 VSS VPW nm1p2_svt_lp W=150e-9 L=60e-9 MR=1
MNM10 net29 ckn net41 VPW nm1p2_svt_lp W=150e-9 L=60e-9 MR=1
MNM8 net35 net29 VSS VPW nm1p2_svt_lp W=230e-9 L=60e-9 MR=1
MNM7 net29 ckb net26 VPW nm1p2_svt_lp W=230e-9 L=60e-9 MR=1
MNM5 net43 net26 VSS VPW nm1p2_svt_lp W=150e-9 L=60e-9 MR=1
MNM6 net17 ckb net43 VPW nm1p2_svt_lp W=150e-9 L=60e-9 MR=1
MNM4 net26 net17 VSS VPW nm1p2_svt_lp W=230e-9 L=60e-9 MR=1
MNM_RN net46 RN VSS VPW nm1p2_svt_lp W=230e-9 L=60e-9 MR=1
MNM2 net45 D net46 VPW nm1p2_svt_lp W=230e-9 L=60e-9 MR=1
MNM3 net17 ckn net45 VPW nm1p2_svt_lp W=230e-9 L=60e-9 MR=1
MNM1 ckb ckn VSS VPW nm1p2_svt_lp W=230e-9 L=60e-9 MR=1
MNM0 ckn CK VSS VPW nm1p2_svt_lp W=230e-9 L=60e-9 MR=1
MPM12 Q net35 VDD VNW pm1p2_svt_lp W=300e-9 L=60e-9 MR=1
MPM10 net29 ckb net42 VNW pm1p2_svt_lp W=150e-9 L=60e-9 MR=1
MPM9 net42 net35 VDD VNW pm1p2_svt_lp W=150e-9 L=60e-9 MR=1
MPM8 net35 net29 VDD VNW pm1p2_svt_lp W=300e-9 L=60e-9 MR=1
MPM7 net29 ckn net26 VNW pm1p2_svt_lp W=300e-9 L=60e-9 MR=1
MPM6 net17 ckn net44 VNW pm1p2_svt_lp W=150e-9 L=60e-9 MR=1
MPM5 net44 net26 VDD VNW pm1p2_svt_lp W=150e-9 L=60e-9 MR=1
MPM4 net26 net17 VDD VNW pm1p2_svt_lp W=300e-9 L=60e-9 MR=1
MPM_RN net13 RN VDD VNW pm1p2_svt_lp W=300e-9 L=60e-9 MR=1
MPM3 net17 ckb net13 VNW pm1p2_svt_lp W=300e-9 L=60e-9 MR=1
MPM2 net13 D VDD VNW pm1p2_svt_lp W=300e-9 L=60e-9 MR=1
MPM1 ckb ckn VDD VNW pm1p2_svt_lp W=300e-9 L=60e-9 MR=1
MPM0 ckn CK VDD VNW pm1p2_svt_lp W=300e-9 L=60e-9 MR=1
.ENDS
.SUBCKT DFFKRNQX1_9TSVT CK D Q RN VDD VSS VNW VPW
MNM12 Q net35 VSS VPW nm1p2_svt_lp W=470e-9 L=60e-9 MR=1
MNM9 net41 net35 VSS VPW nm1p2_svt_lp W=150e-9 L=60e-9 MR=1
MNM10 net29 ckn net41 VPW nm1p2_svt_lp W=150e-9 L=60e-9 MR=1
MNM8 net35 net29 VSS VPW nm1p2_svt_lp W=470e-9 L=60e-9 MR=1
MNM7 net29 ckb net26 VPW nm1p2_svt_lp W=230n L=60n MR=1
MNM5 net43 net26 VSS VPW nm1p2_svt_lp W=150e-9 L=60e-9 MR=1
MNM6 net17 ckb net43 VPW nm1p2_svt_lp W=150e-9 L=60e-9 MR=1
MNM4 net26 net17 VSS VPW nm1p2_svt_lp W=470e-9 L=60e-9 MR=1
MNM_RN net46 RN VSS VPW nm1p2_svt_lp W=230n L=60n MR=1
MNM2 net45 D net46 VPW nm1p2_svt_lp W=230n L=60n MR=1
MNM3 net17 ckn net45 VPW nm1p2_svt_lp W=230n L=60n MR=1
MNM1 ckb ckn VSS VPW nm1p2_svt_lp W=230e-9 L=60e-9 MR=1
MNM0 ckn CK VSS VPW nm1p2_svt_lp W=230e-9 L=60e-9 MR=1
MPM12 Q net35 VDD VNW pm1p2_svt_lp W=590e-9 L=60e-9 MR=1
MPM10 net29 ckb net42 VNW pm1p2_svt_lp W=150e-9 L=60e-9 MR=1
MPM9 net42 net35 VDD VNW pm1p2_svt_lp W=150e-9 L=60e-9 MR=1
MPM8 net35 net29 VDD VNW pm1p2_svt_lp W=590e-9 L=60e-9 MR=1
MPM7 net29 ckn net26 VNW pm1p2_svt_lp W=300n L=60n MR=1
MPM6 net17 ckn net44 VNW pm1p2_svt_lp W=150e-9 L=60e-9 MR=1
MPM5 net44 net26 VDD VNW pm1p2_svt_lp W=150e-9 L=60e-9 MR=1
MPM4 net26 net17 VDD VNW pm1p2_svt_lp W=590e-9 L=60e-9 MR=1
MPM_RN net13 RN VDD VNW pm1p2_svt_lp W=300n L=60n MR=1
MPM3 net17 ckb net13 VNW pm1p2_svt_lp W=300n L=60n MR=1
MPM2 net13 D VDD VNW pm1p2_svt_lp W=300n L=60n MR=1
MPM1 ckb ckn VDD VNW pm1p2_svt_lp W=300e-9 L=60e-9 MR=1
MPM0 ckn CK VDD VNW pm1p2_svt_lp W=300e-9 L=60e-9 MR=1
.ENDS
.SUBCKT DFFKRNQX2_9TSVT CK D Q RN VDD VSS VNW VPW
MNM12 Q net35 VSS VPW nm1p2_svt_lp W=940e-9 L=60e-9 MR=1
MNM9 net41 net35 VSS VPW nm1p2_svt_lp W=150e-9 L=60e-9 MR=1
MNM10 net29 ckn net41 VPW nm1p2_svt_lp W=150e-9 L=60e-9 MR=1
MNM8 net35 net29 VSS VPW nm1p2_svt_lp W=470e-9 L=60e-9 MR=1
MNM7 net29 ckb net26 VPW nm1p2_svt_lp W=230n L=60n MR=1
MNM5 net43 net26 VSS VPW nm1p2_svt_lp W=150e-9 L=60e-9 MR=1
MNM6 net17 ckb net43 VPW nm1p2_svt_lp W=150e-9 L=60e-9 MR=1
MNM4 net26 net17 VSS VPW nm1p2_svt_lp W=470e-9 L=60e-9 MR=1
MNM_RN net46 RN VSS VPW nm1p2_svt_lp W=470e-9 L=60e-9 MR=1
MNM2 net45 D net46 VPW nm1p2_svt_lp W=470e-9 L=60e-9 MR=1
MNM3 net17 ckn net45 VPW nm1p2_svt_lp W=470e-9 L=60e-9 MR=1
MNM1 ckb ckn VSS VPW nm1p2_svt_lp W=230e-9 L=60e-9 MR=1
MNM0 ckn CK VSS VPW nm1p2_svt_lp W=230e-9 L=60e-9 MR=1
MPM12 Q net35 VDD VNW pm1p2_svt_lp W=1.18e-6 L=60e-9 MR=1
MPM10 net29 ckb net42 VNW pm1p2_svt_lp W=150e-9 L=60e-9 MR=1
MPM9 net42 net35 VDD VNW pm1p2_svt_lp W=150e-9 L=60e-9 MR=1
MPM8 net35 net29 VDD VNW pm1p2_svt_lp W=590e-9 L=60e-9 MR=1
MPM7 net29 ckn net26 VNW pm1p2_svt_lp W=300n L=60n MR=1
MPM6 net17 ckn net44 VNW pm1p2_svt_lp W=150e-9 L=60e-9 MR=1
MPM5 net44 net26 VDD VNW pm1p2_svt_lp W=150e-9 L=60e-9 MR=1
MPM4 net26 net17 VDD VNW pm1p2_svt_lp W=590e-9 L=60e-9 MR=1
MPM_RN net13 RN VDD VNW pm1p2_svt_lp W=590e-9 L=60e-9 MR=1
MPM3 net17 ckb net13 VNW pm1p2_svt_lp W=590e-9 L=60e-9 MR=1
MPM2 net13 D VDD VNW pm1p2_svt_lp W=590e-9 L=60e-9 MR=1
MPM1 ckb ckn VDD VNW pm1p2_svt_lp W=300e-9 L=60e-9 MR=1
MPM0 ckn CK VDD VNW pm1p2_svt_lp W=300e-9 L=60e-9 MR=1
.ENDS
.SUBCKT DFFKRNQX4_9TSVT CK D Q RN VDD VSS VNW VPW
MNM12 Q net35 VSS VPW nm1p2_svt_lp W=1.88e-6 L=60e-9 MR=1
MNM9 net41 net35 VSS VPW nm1p2_svt_lp W=150e-9 L=60e-9 MR=1
MNM10 net29 ckn net41 VPW nm1p2_svt_lp W=150e-9 L=60e-9 MR=1
MNM8 net35 net29 VSS VPW nm1p2_svt_lp W=940e-9 L=60e-9 MR=1
MNM7 net29 ckb net26 VPW nm1p2_svt_lp W=230n L=60n MR=1
MNM5 net43 net26 VSS VPW nm1p2_svt_lp W=150e-9 L=60e-9 MR=1
MNM6 net17 ckb net43 VPW nm1p2_svt_lp W=150e-9 L=60e-9 MR=1
MNM4 net26 net17 VSS VPW nm1p2_svt_lp W=470e-9 L=60e-9 MR=1
MNM_RN net46 RN VSS VPW nm1p2_svt_lp W=470e-9 L=60e-9 MR=1
MNM2 net45 D net46 VPW nm1p2_svt_lp W=470e-9 L=60e-9 MR=1
MNM3 net17 ckn net45 VPW nm1p2_svt_lp W=470e-9 L=60e-9 MR=1
MNM1 ckb ckn VSS VPW nm1p2_svt_lp W=230n L=60n MR=1
MNM0 ckn CK VSS VPW nm1p2_svt_lp W=230n L=60n MR=1
MPM12 Q net35 VDD VNW pm1p2_svt_lp W=2.36e-6 L=60e-9 MR=1
MPM10 net29 ckb net42 VNW pm1p2_svt_lp W=150e-9 L=60e-9 MR=1
MPM9 net42 net35 VDD VNW pm1p2_svt_lp W=150e-9 L=60e-9 MR=1
MPM8 net35 net29 VDD VNW pm1p2_svt_lp W=1.18e-6 L=60e-9 MR=1
MPM7 net29 ckn net26 VNW pm1p2_svt_lp W=300n L=60n MR=1
MPM6 net17 ckn net44 VNW pm1p2_svt_lp W=150e-9 L=60e-9 MR=1
MPM5 net44 net26 VDD VNW pm1p2_svt_lp W=150e-9 L=60e-9 MR=1
MPM4 net26 net17 VDD VNW pm1p2_svt_lp W=590e-9 L=60e-9 MR=1
MPM_RN net13 RN VDD VNW pm1p2_svt_lp W=590e-9 L=60e-9 MR=1
MPM3 net17 ckb net13 VNW pm1p2_svt_lp W=590e-9 L=60e-9 MR=1
MPM2 net13 D VDD VNW pm1p2_svt_lp W=590e-9 L=60e-9 MR=1
MPM1 ckb ckn VDD VNW pm1p2_svt_lp W=300n L=60n MR=1
MPM0 ckn CK VDD VNW pm1p2_svt_lp W=300n L=60n MR=1
.ENDS
.SUBCKT DFFKRSNQX0P5_9TSVT CK D Q RN SN VDD VSS VNW VPW
MNM12 Q net41 VSS VPW nm1p2_svt_lp W=230e-9 L=60e-9 MR=1
MNM10 net48 net41 VSS VPW nm1p2_svt_lp W=150e-9 L=60e-9 MR=1
MNM11 net35 ckn net48 VPW nm1p2_svt_lp W=150e-9 L=60e-9 MR=1
MNM9 net41 net35 VSS VPW nm1p2_svt_lp W=230e-9 L=60e-9 MR=1
MNM8 net35 ckb net32 VPW nm1p2_svt_lp W=230e-9 L=60e-9 MR=1
MNM6 net50 net32 VSS VPW nm1p2_svt_lp W=150e-9 L=60e-9 MR=1
MNM7 net23 ckb net50 VPW nm1p2_svt_lp W=150e-9 L=60e-9 MR=1
MNM5 net32 net23 VSS VPW nm1p2_svt_lp W=230e-9 L=60e-9 MR=1
MNM_SN net45 SNN net17 VPW nm1p2_svt_lp W=230e-9 L=60e-9 MR=1
MNM_RN net17 RN VSS VPW nm1p2_svt_lp W=230e-9 L=60e-9 MR=1
MNM3 net45 D net17 VPW nm1p2_svt_lp W=230e-9 L=60e-9 MR=1
MNM4 net23 ckn net45 VPW nm1p2_svt_lp W=230e-9 L=60e-9 MR=1
MNM2 SNN SN VSS VPW nm1p2_svt_lp W=230e-9 L=60e-9 MR=1
MNM1 ckb ckn VSS VPW nm1p2_svt_lp W=230e-9 L=60e-9 MR=1
MNM0 ckn CK VSS VPW nm1p2_svt_lp W=230e-9 L=60e-9 MR=1
MPM12 Q net41 VDD VNW pm1p2_svt_lp W=300e-9 L=60e-9 MR=1
MPM11 net35 ckb net49 VNW pm1p2_svt_lp W=150e-9 L=60e-9 MR=1
MPM10 net49 net41 VDD VNW pm1p2_svt_lp W=150e-9 L=60e-9 MR=1
MPM9 net41 net35 VDD VNW pm1p2_svt_lp W=300e-9 L=60e-9 MR=1
MPM8 net35 ckn net32 VNW pm1p2_svt_lp W=300e-9 L=60e-9 MR=1
MPM7 net23 ckn net51 VNW pm1p2_svt_lp W=150e-9 L=60e-9 MR=1
MPM6 net51 net32 VDD VNW pm1p2_svt_lp W=150e-9 L=60e-9 MR=1
MPM5 net32 net23 VDD VNW pm1p2_svt_lp W=300e-9 L=60e-9 MR=1
MPM_SN net52 SNN VDD VNW pm1p2_svt_lp W=300e-9 L=60e-9 MR=1
MPM_RN net19 RN VDD VNW pm1p2_svt_lp W=300e-9 L=60e-9 MR=1
MPM4 net23 ckb net19 VNW pm1p2_svt_lp W=300e-9 L=60e-9 MR=1
MPM3 net19 D net52 VNW pm1p2_svt_lp W=300e-9 L=60e-9 MR=1
MPM2 SNN SN VDD VNW pm1p2_svt_lp W=300e-9 L=60e-9 MR=1
MPM1 ckb ckn VDD VNW pm1p2_svt_lp W=300e-9 L=60e-9 MR=1
MPM0 ckn CK VDD VNW pm1p2_svt_lp W=300e-9 L=60e-9 MR=1
.ENDS
.SUBCKT DFFKRSNQX1_9TSVT CK D Q RN SN VDD VSS VNW VPW
MNM12 Q net41 VSS VPW nm1p2_svt_lp W=470e-9 L=60e-9 MR=1
MNM10 net48 net41 VSS VPW nm1p2_svt_lp W=150e-9 L=60e-9 MR=1
MNM11 net35 ckn net48 VPW nm1p2_svt_lp W=150e-9 L=60e-9 MR=1
MNM9 net41 net35 VSS VPW nm1p2_svt_lp W=470e-9 L=60e-9 MR=1
MNM8 net35 ckb net32 VPW nm1p2_svt_lp W=230n L=60n MR=1
MNM6 net50 net32 VSS VPW nm1p2_svt_lp W=150e-9 L=60e-9 MR=1
MNM7 net23 ckb net50 VPW nm1p2_svt_lp W=150e-9 L=60e-9 MR=1
MNM5 net32 net23 VSS VPW nm1p2_svt_lp W=470e-9 L=60e-9 MR=1
MNM_SN net45 SNN net17 VPW nm1p2_svt_lp W=230n L=60n MR=1
MNM_RN net17 RN VSS VPW nm1p2_svt_lp W=230n L=60n MR=1
MNM3 net45 D net17 VPW nm1p2_svt_lp W=230n L=60n MR=1
MNM4 net23 ckn net45 VPW nm1p2_svt_lp W=230n L=60n MR=1
MNM2 SNN SN VSS VPW nm1p2_svt_lp W=230e-9 L=60e-9 MR=1
MNM1 ckb ckn VSS VPW nm1p2_svt_lp W=230e-9 L=60e-9 MR=1
MNM0 ckn CK VSS VPW nm1p2_svt_lp W=230e-9 L=60e-9 MR=1
MPM12 Q net41 VDD VNW pm1p2_svt_lp W=590e-9 L=60e-9 MR=1
MPM11 net35 ckb net49 VNW pm1p2_svt_lp W=150e-9 L=60e-9 MR=1
MPM10 net49 net41 VDD VNW pm1p2_svt_lp W=150e-9 L=60e-9 MR=1
MPM9 net41 net35 VDD VNW pm1p2_svt_lp W=590e-9 L=60e-9 MR=1
MPM8 net35 ckn net32 VNW pm1p2_svt_lp W=300n L=60n MR=1
MPM7 net23 ckn net51 VNW pm1p2_svt_lp W=150e-9 L=60e-9 MR=1
MPM6 net51 net32 VDD VNW pm1p2_svt_lp W=150e-9 L=60e-9 MR=1
MPM5 net32 net23 VDD VNW pm1p2_svt_lp W=410e-9 L=60e-9 MR=1
MPM_SN net52 SNN VDD VNW pm1p2_svt_lp W=300n L=60n MR=1
MPM_RN net19 RN VDD VNW pm1p2_svt_lp W=300n L=60n MR=1
MPM4 net23 ckb net19 VNW pm1p2_svt_lp W=300n L=60n MR=1
MPM3 net19 D net52 VNW pm1p2_svt_lp W=300n L=60n MR=1
MPM2 SNN SN VDD VNW pm1p2_svt_lp W=300e-9 L=60e-9 MR=1
MPM1 ckb ckn VDD VNW pm1p2_svt_lp W=300e-9 L=60e-9 MR=1
MPM0 ckn CK VDD VNW pm1p2_svt_lp W=300e-9 L=60e-9 MR=1
.ENDS
.SUBCKT DFFKRSNQX2_9TSVT CK D Q RN SN VDD VSS VNW VPW
MNM12 Q net41 VSS VPW nm1p2_svt_lp W=940e-9 L=60e-9 MR=1
MNM10 net48 net41 VSS VPW nm1p2_svt_lp W=150e-9 L=60e-9 MR=1
MNM11 net35 ckn net48 VPW nm1p2_svt_lp W=150e-9 L=60e-9 MR=1
MNM9 net41 net35 VSS VPW nm1p2_svt_lp W=470e-9 L=60e-9 MR=1
MNM8 net35 ckb net32 VPW nm1p2_svt_lp W=230n L=60n MR=1
MNM6 net50 net32 VSS VPW nm1p2_svt_lp W=150e-9 L=60e-9 MR=1
MNM7 net23 ckb net50 VPW nm1p2_svt_lp W=150e-9 L=60e-9 MR=1
MNM5 net32 net23 VSS VPW nm1p2_svt_lp W=470e-9 L=60e-9 MR=1
MNM_SN net45 SNN net17 VPW nm1p2_svt_lp W=470e-9 L=60e-9 MR=1
MNM_RN net17 RN VSS VPW nm1p2_svt_lp W=470e-9 L=60e-9 MR=1
MNM3 net45 D net17 VPW nm1p2_svt_lp W=470e-9 L=60e-9 MR=1
MNM4 net23 ckn net45 VPW nm1p2_svt_lp W=470e-9 L=60e-9 MR=1
MNM2 SNN SN VSS VPW nm1p2_svt_lp W=230e-9 L=60e-9 MR=1
MNM1 ckb ckn VSS VPW nm1p2_svt_lp W=230e-9 L=60e-9 MR=1
MNM0 ckn CK VSS VPW nm1p2_svt_lp W=230e-9 L=60e-9 MR=1
MPM12 Q net41 VDD VNW pm1p2_svt_lp W=1.18e-6 L=60e-9 MR=1
MPM11 net35 ckb net49 VNW pm1p2_svt_lp W=150e-9 L=60e-9 MR=1
MPM10 net49 net41 VDD VNW pm1p2_svt_lp W=150e-9 L=60e-9 MR=1
MPM9 net41 net35 VDD VNW pm1p2_svt_lp W=590e-9 L=60e-9 MR=1
MPM8 net35 ckn net32 VNW pm1p2_svt_lp W=300n L=60n MR=1
MPM7 net23 ckn net51 VNW pm1p2_svt_lp W=150e-9 L=60e-9 MR=1
MPM6 net51 net32 VDD VNW pm1p2_svt_lp W=150e-9 L=60e-9 MR=1
MPM5 net32 net23 VDD VNW pm1p2_svt_lp W=410e-9 L=60e-9 MR=1
MPM_SN net52 SNN VDD VNW pm1p2_svt_lp W=590e-9 L=60e-9 MR=1
MPM_RN net19 RN VDD VNW pm1p2_svt_lp W=590e-9 L=60e-9 MR=1
MPM4 net23 ckb net19 VNW pm1p2_svt_lp W=410e-9 L=60e-9 MR=1
MPM3 net19 D net52 VNW pm1p2_svt_lp W=590e-9 L=60e-9 MR=1
MPM2 SNN SN VDD VNW pm1p2_svt_lp W=300e-9 L=60e-9 MR=1
MPM1 ckb ckn VDD VNW pm1p2_svt_lp W=300e-9 L=60e-9 MR=1
MPM0 ckn CK VDD VNW pm1p2_svt_lp W=300e-9 L=60e-9 MR=1
.ENDS
.SUBCKT DFFKRSNQX4_9TSVT CK D Q RN SN VDD VSS VNW VPW
MNM12 Q net41 VSS VPW nm1p2_svt_lp W=1.88e-6 L=60e-9 MR=1
MNM10 net48 net41 VSS VPW nm1p2_svt_lp W=150e-9 L=60e-9 MR=1
MNM11 net35 ckn net48 VPW nm1p2_svt_lp W=150e-9 L=60e-9 MR=1
MNM9 net41 net35 VSS VPW nm1p2_svt_lp W=940e-9 L=60e-9 MR=1
MNM8 net35 ckb net32 VPW nm1p2_svt_lp W=230n L=60n MR=1
MNM6 net50 net32 VSS VPW nm1p2_svt_lp W=150e-9 L=60e-9 MR=1
MNM7 net23 ckb net50 VPW nm1p2_svt_lp W=150e-9 L=60e-9 MR=1
MNM5 net32 net23 VSS VPW nm1p2_svt_lp W=470e-9 L=60e-9 MR=1
MNM_SN net45 SNN net17 VPW nm1p2_svt_lp W=470e-9 L=60e-9 MR=1
MNM_RN net17 RN VSS VPW nm1p2_svt_lp W=470e-9 L=60e-9 MR=1
MNM3 net45 D net17 VPW nm1p2_svt_lp W=470e-9 L=60e-9 MR=1
MNM4 net23 ckn net45 VPW nm1p2_svt_lp W=470e-9 L=60e-9 MR=1
MNM2 SNN SN VSS VPW nm1p2_svt_lp W=230e-9 L=60e-9 MR=1
MNM1 ckb ckn VSS VPW nm1p2_svt_lp W=230n L=60n MR=1
MNM0 ckn CK VSS VPW nm1p2_svt_lp W=230n L=60n MR=1
MPM12 Q net41 VDD VNW pm1p2_svt_lp W=2.36e-6 L=60e-9 MR=1
MPM11 net35 ckb net49 VNW pm1p2_svt_lp W=150e-9 L=60e-9 MR=1
MPM10 net49 net41 VDD VNW pm1p2_svt_lp W=150e-9 L=60e-9 MR=1
MPM9 net41 net35 VDD VNW pm1p2_svt_lp W=1.18e-6 L=60e-9 MR=1
MPM8 net35 ckn net32 VNW pm1p2_svt_lp W=300n L=60n MR=1
MPM7 net23 ckn net51 VNW pm1p2_svt_lp W=150e-9 L=60e-9 MR=1
MPM6 net51 net32 VDD VNW pm1p2_svt_lp W=150e-9 L=60e-9 MR=1
MPM5 net32 net23 VDD VNW pm1p2_svt_lp W=410e-9 L=60e-9 MR=1
MPM_SN net52 SNN VDD VNW pm1p2_svt_lp W=590e-9 L=60e-9 MR=1
MPM_RN net19 RN VDD VNW pm1p2_svt_lp W=590e-9 L=60e-9 MR=1
MPM4 net23 ckb net19 VNW pm1p2_svt_lp W=410e-9 L=60e-9 MR=1
MPM3 net19 D net52 VNW pm1p2_svt_lp W=590e-9 L=60e-9 MR=1
MPM2 SNN SN VDD VNW pm1p2_svt_lp W=300e-9 L=60e-9 MR=1
MPM1 ckb ckn VDD VNW pm1p2_svt_lp W=300n L=60n MR=1
MPM0 ckn CK VDD VNW pm1p2_svt_lp W=300n L=60n MR=1
.ENDS
.SUBCKT DFFKSNQX0P5_9TSVT CK D Q SN VDD VSS VNW VPW
MNM12 Q net38 VSS VPW nm1p2_svt_lp W=230e-9 L=60e-9 MR=1
MNM10 net45 net38 VSS VPW nm1p2_svt_lp W=150e-9 L=60e-9 MR=1
MNM11 net32 ckn net45 VPW nm1p2_svt_lp W=150e-9 L=60e-9 MR=1
MNM9 net38 net32 VSS VPW nm1p2_svt_lp W=230e-9 L=60e-9 MR=1
MNM8 net32 ckb net29 VPW nm1p2_svt_lp W=230e-9 L=60e-9 MR=1
MNM6 net47 net29 VSS VPW nm1p2_svt_lp W=150e-9 L=60e-9 MR=1
MNM7 net20 ckb net47 VPW nm1p2_svt_lp W=150e-9 L=60e-9 MR=1
MNM5 net29 net20 VSS VPW nm1p2_svt_lp W=230e-9 L=60e-9 MR=1
MNM_SN net42 SNN VSS VPW nm1p2_svt_lp W=230e-9 L=60e-9 MR=1
MNM3 net42 D VSS VPW nm1p2_svt_lp W=230e-9 L=60e-9 MR=1
MNM4 net20 ckn net42 VPW nm1p2_svt_lp W=230e-9 L=60e-9 MR=1
MNM2 SNN SN VSS VPW nm1p2_svt_lp W=230e-9 L=60e-9 MR=1
MNM1 ckb ckn VSS VPW nm1p2_svt_lp W=230e-9 L=60e-9 MR=1
MNM0 ckn CK VSS VPW nm1p2_svt_lp W=230e-9 L=60e-9 MR=1
MPM12 Q net38 VDD VNW pm1p2_svt_lp W=300e-9 L=60e-9 MR=1
MPM11 net32 ckb net46 VNW pm1p2_svt_lp W=150e-9 L=60e-9 MR=1
MPM10 net46 net38 VDD VNW pm1p2_svt_lp W=150e-9 L=60e-9 MR=1
MPM9 net38 net32 VDD VNW pm1p2_svt_lp W=300e-9 L=60e-9 MR=1
MPM8 net32 ckn net29 VNW pm1p2_svt_lp W=300e-9 L=60e-9 MR=1
MPM7 net20 ckn net48 VNW pm1p2_svt_lp W=150e-9 L=60e-9 MR=1
MPM6 net48 net29 VDD VNW pm1p2_svt_lp W=150e-9 L=60e-9 MR=1
MPM5 net29 net20 VDD VNW pm1p2_svt_lp W=300e-9 L=60e-9 MR=1
MPM_SN net49 SNN VDD VNW pm1p2_svt_lp W=300e-9 L=60e-9 MR=1
MPM4 net20 ckb net42 VNW pm1p2_svt_lp W=300e-9 L=60e-9 MR=1
MPM3 net42 D net49 VNW pm1p2_svt_lp W=300e-9 L=60e-9 MR=1
MPM2 SNN SN VDD VNW pm1p2_svt_lp W=300e-9 L=60e-9 MR=1
MPM1 ckb ckn VDD VNW pm1p2_svt_lp W=300e-9 L=60e-9 MR=1
MPM0 ckn CK VDD VNW pm1p2_svt_lp W=300e-9 L=60e-9 MR=1
.ENDS
.SUBCKT DFFKSNQX1_9TSVT CK D Q SN VDD VSS VNW VPW
MNM12 Q net38 VSS VPW nm1p2_svt_lp W=470e-9 L=60e-9 MR=1
MNM10 net45 net38 VSS VPW nm1p2_svt_lp W=150e-9 L=60e-9 MR=1
MNM11 net32 ckn net45 VPW nm1p2_svt_lp W=150e-9 L=60e-9 MR=1
MNM9 net38 net32 VSS VPW nm1p2_svt_lp W=470e-9 L=60e-9 MR=1
MNM8 net32 ckb net29 VPW nm1p2_svt_lp W=230n L=60n MR=1
MNM6 net47 net29 VSS VPW nm1p2_svt_lp W=150e-9 L=60e-9 MR=1
MNM7 net20 ckb net47 VPW nm1p2_svt_lp W=150e-9 L=60e-9 MR=1
MNM5 net29 net20 VSS VPW nm1p2_svt_lp W=470e-9 L=60e-9 MR=1
MNM_SN net42 SNN VSS VPW nm1p2_svt_lp W=230n L=60n MR=1
MNM3 net42 D VSS VPW nm1p2_svt_lp W=230n L=60n MR=1
MNM4 net20 ckn net42 VPW nm1p2_svt_lp W=230n L=60n MR=1
MNM2 SNN SN VSS VPW nm1p2_svt_lp W=230e-9 L=60e-9 MR=1
MNM1 ckb ckn VSS VPW nm1p2_svt_lp W=230e-9 L=60e-9 MR=1
MNM0 ckn CK VSS VPW nm1p2_svt_lp W=230e-9 L=60e-9 MR=1
MPM12 Q net38 VDD VNW pm1p2_svt_lp W=590e-9 L=60e-9 MR=1
MPM11 net32 ckb net46 VNW pm1p2_svt_lp W=150e-9 L=60e-9 MR=1
MPM10 net46 net38 VDD VNW pm1p2_svt_lp W=150e-9 L=60e-9 MR=1
MPM9 net38 net32 VDD VNW pm1p2_svt_lp W=590e-9 L=60e-9 MR=1
MPM8 net32 ckn net29 VNW pm1p2_svt_lp W=300n L=60n MR=1
MPM7 net20 ckn net48 VNW pm1p2_svt_lp W=150e-9 L=60e-9 MR=1
MPM6 net48 net29 VDD VNW pm1p2_svt_lp W=150e-9 L=60e-9 MR=1
MPM5 net29 net20 VDD VNW pm1p2_svt_lp W=410e-9 L=60e-9 MR=1
MPM_SN net49 SNN VDD VNW pm1p2_svt_lp W=300n L=60n MR=1
MPM4 net20 ckb net42 VNW pm1p2_svt_lp W=300n L=60n MR=1
MPM3 net42 D net49 VNW pm1p2_svt_lp W=300n L=60n MR=1
MPM2 SNN SN VDD VNW pm1p2_svt_lp W=300e-9 L=60e-9 MR=1
MPM1 ckb ckn VDD VNW pm1p2_svt_lp W=300e-9 L=60e-9 MR=1
MPM0 ckn CK VDD VNW pm1p2_svt_lp W=300e-9 L=60e-9 MR=1
.ENDS
.SUBCKT DFFKSNQX2_9TSVT CK D Q SN VDD VSS VNW VPW
MNM12 Q net38 VSS VPW nm1p2_svt_lp W=940e-9 L=60e-9 MR=1
MNM10 net45 net38 VSS VPW nm1p2_svt_lp W=150e-9 L=60e-9 MR=1
MNM11 net32 ckn net45 VPW nm1p2_svt_lp W=150e-9 L=60e-9 MR=1
MNM9 net38 net32 VSS VPW nm1p2_svt_lp W=470e-9 L=60e-9 MR=1
MNM8 net32 ckb net29 VPW nm1p2_svt_lp W=230n L=60n MR=1
MNM6 net47 net29 VSS VPW nm1p2_svt_lp W=150e-9 L=60e-9 MR=1
MNM7 net20 ckb net47 VPW nm1p2_svt_lp W=150e-9 L=60e-9 MR=1
MNM5 net29 net20 VSS VPW nm1p2_svt_lp W=470e-9 L=60e-9 MR=1
MNM_SN net42 SNN VSS VPW nm1p2_svt_lp W=470e-9 L=60e-9 MR=1
MNM3 net42 D VSS VPW nm1p2_svt_lp W=470e-9 L=60e-9 MR=1
MNM4 net20 ckn net42 VPW nm1p2_svt_lp W=470e-9 L=60e-9 MR=1
MNM2 SNN SN VSS VPW nm1p2_svt_lp W=230e-9 L=60e-9 MR=1
MNM1 ckb ckn VSS VPW nm1p2_svt_lp W=230e-9 L=60e-9 MR=1
MNM0 ckn CK VSS VPW nm1p2_svt_lp W=230e-9 L=60e-9 MR=1
MPM12 Q net38 VDD VNW pm1p2_svt_lp W=1.18e-6 L=60e-9 MR=1
MPM11 net32 ckb net46 VNW pm1p2_svt_lp W=150e-9 L=60e-9 MR=1
MPM10 net46 net38 VDD VNW pm1p2_svt_lp W=150e-9 L=60e-9 MR=1
MPM9 net38 net32 VDD VNW pm1p2_svt_lp W=590e-9 L=60e-9 MR=1
MPM8 net32 ckn net29 VNW pm1p2_svt_lp W=300n L=60n MR=1
MPM7 net20 ckn net48 VNW pm1p2_svt_lp W=150e-9 L=60e-9 MR=1
MPM6 net48 net29 VDD VNW pm1p2_svt_lp W=150e-9 L=60e-9 MR=1
MPM5 net29 net20 VDD VNW pm1p2_svt_lp W=410e-9 L=60e-9 MR=1
MPM_SN net49 SNN VDD VNW pm1p2_svt_lp W=590e-9 L=60e-9 MR=1
MPM4 net20 ckb net42 VNW pm1p2_svt_lp W=410e-9 L=60e-9 MR=1
MPM3 net42 D net49 VNW pm1p2_svt_lp W=590e-9 L=60e-9 MR=1
MPM2 SNN SN VDD VNW pm1p2_svt_lp W=300e-9 L=60e-9 MR=1
MPM1 ckb ckn VDD VNW pm1p2_svt_lp W=300e-9 L=60e-9 MR=1
MPM0 ckn CK VDD VNW pm1p2_svt_lp W=300e-9 L=60e-9 MR=1
.ENDS
.SUBCKT DFFKSNQX4_9TSVT CK D Q SN VDD VSS VNW VPW
MNM12 Q net38 VSS VPW nm1p2_svt_lp W=1.88e-6 L=60e-9 MR=1
MNM10 net45 net38 VSS VPW nm1p2_svt_lp W=150e-9 L=60e-9 MR=1
MNM11 net32 ckn net45 VPW nm1p2_svt_lp W=150e-9 L=60e-9 MR=1
MNM9 net38 net32 VSS VPW nm1p2_svt_lp W=940e-9 L=60e-9 MR=1
MNM8 net32 ckb net29 VPW nm1p2_svt_lp W=230n L=60n MR=1
MNM6 net47 net29 VSS VPW nm1p2_svt_lp W=150e-9 L=60e-9 MR=1
MNM7 net20 ckb net47 VPW nm1p2_svt_lp W=150e-9 L=60e-9 MR=1
MNM5 net29 net20 VSS VPW nm1p2_svt_lp W=470e-9 L=60e-9 MR=1
MNM_SN net42 SNN VSS VPW nm1p2_svt_lp W=470e-9 L=60e-9 MR=1
MNM3 net42 D VSS VPW nm1p2_svt_lp W=470e-9 L=60e-9 MR=1
MNM4 net20 ckn net42 VPW nm1p2_svt_lp W=470e-9 L=60e-9 MR=1
MNM2 SNN SN VSS VPW nm1p2_svt_lp W=230e-9 L=60e-9 MR=1
MNM1 ckb ckn VSS VPW nm1p2_svt_lp W=230n L=60n MR=1
MNM0 ckn CK VSS VPW nm1p2_svt_lp W=230n L=60n MR=1
MPM12 Q net38 VDD VNW pm1p2_svt_lp W=2.36e-6 L=60e-9 MR=1
MPM11 net32 ckb net46 VNW pm1p2_svt_lp W=150e-9 L=60e-9 MR=1
MPM10 net46 net38 VDD VNW pm1p2_svt_lp W=150e-9 L=60e-9 MR=1
MPM9 net38 net32 VDD VNW pm1p2_svt_lp W=1.18e-6 L=60e-9 MR=1
MPM8 net32 ckn net29 VNW pm1p2_svt_lp W=300n L=60n MR=1
MPM7 net20 ckn net48 VNW pm1p2_svt_lp W=150e-9 L=60e-9 MR=1
MPM6 net48 net29 VDD VNW pm1p2_svt_lp W=150e-9 L=60e-9 MR=1
MPM5 net29 net20 VDD VNW pm1p2_svt_lp W=410e-9 L=60e-9 MR=1
MPM_SN net49 SNN VDD VNW pm1p2_svt_lp W=590e-9 L=60e-9 MR=1
MPM4 net20 ckb net42 VNW pm1p2_svt_lp W=410e-9 L=60e-9 MR=1
MPM3 net42 D net49 VNW pm1p2_svt_lp W=590e-9 L=60e-9 MR=1
MPM2 SNN SN VDD VNW pm1p2_svt_lp W=300e-9 L=60e-9 MR=1
MPM1 ckb ckn VDD VNW pm1p2_svt_lp W=300n L=60n MR=1
MPM0 ckn CK VDD VNW pm1p2_svt_lp W=300n L=60n MR=1
.ENDS
.SUBCKT DFFNQX0P5_9TSVT CKN D Q VDD VSS VNW VPW
MNM11 Q net32 VSS VPW nm1p2_svt_lp W=230e-9 L=60e-9 MR=1
MNM9 net38 net32 VSS VPW nm1p2_svt_lp W=150e-9 L=60e-9 MR=1
MNM10 net26 ckb net38 VPW nm1p2_svt_lp W=150e-9 L=60e-9 MR=1
MNM8 net32 net26 VSS VPW nm1p2_svt_lp W=230e-9 L=60e-9 MR=1
MNM7 net26 cknn net23 VPW nm1p2_svt_lp W=230e-9 L=60e-9 MR=1
MNM5 net40 net23 VSS VPW nm1p2_svt_lp W=150e-9 L=60e-9 MR=1
MNM6 net14 cknn net40 VPW nm1p2_svt_lp W=150e-9 L=60e-9 MR=1
MNM4 net23 net14 VSS VPW nm1p2_svt_lp W=230e-9 L=60e-9 MR=1
MNM2 net42 D VSS VPW nm1p2_svt_lp W=230e-9 L=60e-9 MR=1
MNM3 net14 ckb net42 VPW nm1p2_svt_lp W=230e-9 L=60e-9 MR=1
MNM1 ckb cknn VSS VPW nm1p2_svt_lp W=230e-9 L=60e-9 MR=1
MNM0 cknn CKN VSS VPW nm1p2_svt_lp W=230e-9 L=60e-9 MR=1
MPM11 Q net32 VDD VNW pm1p2_svt_lp W=300e-9 L=60e-9 MR=1
MPM10 net26 cknn net39 VNW pm1p2_svt_lp W=150e-9 L=60e-9 MR=1
MPM9 net39 net32 VDD VNW pm1p2_svt_lp W=150e-9 L=60e-9 MR=1
MPM8 net32 net26 VDD VNW pm1p2_svt_lp W=300e-9 L=60e-9 MR=1
MPM7 net26 ckb net23 VNW pm1p2_svt_lp W=300e-9 L=60e-9 MR=1
MPM6 net14 ckb net41 VNW pm1p2_svt_lp W=150e-9 L=60e-9 MR=1
MPM5 net41 net23 VDD VNW pm1p2_svt_lp W=150e-9 L=60e-9 MR=1
MPM4 net23 net14 VDD VNW pm1p2_svt_lp W=300e-9 L=60e-9 MR=1
MPM3 net14 cknn net43 VNW pm1p2_svt_lp W=300e-9 L=60e-9 MR=1
MPM2 net43 D VDD VNW pm1p2_svt_lp W=300e-9 L=60e-9 MR=1
MPM1 ckb cknn VDD VNW pm1p2_svt_lp W=300e-9 L=60e-9 MR=1
MPM0 cknn CKN VDD VNW pm1p2_svt_lp W=300e-9 L=60e-9 MR=1
.ENDS
.SUBCKT DFFNQX1_9TSVT CKN D Q VDD VSS VNW VPW
MNM11 Q net32 VSS VPW nm1p2_svt_lp W=470e-9 L=60e-9 MR=1
MNM9 net38 net32 VSS VPW nm1p2_svt_lp W=150e-9 L=60e-9 MR=1
MNM10 net26 ckb net38 VPW nm1p2_svt_lp W=150e-9 L=60e-9 MR=1
MNM8 net32 net26 VSS VPW nm1p2_svt_lp W=470e-9 L=60e-9 MR=1
MNM7 net26 cknn net23 VPW nm1p2_svt_lp W=230n L=60n MR=1
MNM5 net40 net23 VSS VPW nm1p2_svt_lp W=150e-9 L=60e-9 MR=1
MNM6 net14 cknn net40 VPW nm1p2_svt_lp W=150e-9 L=60e-9 MR=1
MNM4 net23 net14 VSS VPW nm1p2_svt_lp W=470e-9 L=60e-9 MR=1
MNM2 net42 D VSS VPW nm1p2_svt_lp W=230n L=60n MR=1
MNM3 net14 ckb net42 VPW nm1p2_svt_lp W=230n L=60n MR=1
MNM1 ckb cknn VSS VPW nm1p2_svt_lp W=230e-9 L=60e-9 MR=1
MNM0 cknn CKN VSS VPW nm1p2_svt_lp W=230e-9 L=60e-9 MR=1
MPM11 Q net32 VDD VNW pm1p2_svt_lp W=590e-9 L=60e-9 MR=1
MPM10 net26 cknn net39 VNW pm1p2_svt_lp W=150e-9 L=60e-9 MR=1
MPM9 net39 net32 VDD VNW pm1p2_svt_lp W=150e-9 L=60e-9 MR=1
MPM8 net32 net26 VDD VNW pm1p2_svt_lp W=590e-9 L=60e-9 MR=1
MPM7 net26 ckb net23 VNW pm1p2_svt_lp W=300n L=60n MR=1
MPM6 net14 ckb net41 VNW pm1p2_svt_lp W=150e-9 L=60e-9 MR=1
MPM5 net41 net23 VDD VNW pm1p2_svt_lp W=150e-9 L=60e-9 MR=1
MPM4 net23 net14 VDD VNW pm1p2_svt_lp W=590e-9 L=60e-9 MR=1
MPM3 net14 cknn net43 VNW pm1p2_svt_lp W=300n L=60n MR=1
MPM2 net43 D VDD VNW pm1p2_svt_lp W=300n L=60n MR=1
MPM1 ckb cknn VDD VNW pm1p2_svt_lp W=300e-9 L=60e-9 MR=1
MPM0 cknn CKN VDD VNW pm1p2_svt_lp W=300e-9 L=60e-9 MR=1
.ENDS
.SUBCKT DFFNQX2_9TSVT CKN D Q VDD VSS VNW VPW
MNM11 Q net32 VSS VPW nm1p2_svt_lp W=940e-9 L=60e-9 MR=1
MNM9 net38 net32 VSS VPW nm1p2_svt_lp W=150e-9 L=60e-9 MR=1
MNM10 net26 ckb net38 VPW nm1p2_svt_lp W=150e-9 L=60e-9 MR=1
MNM8 net32 net26 VSS VPW nm1p2_svt_lp W=470e-9 L=60e-9 MR=1
MNM7 net26 cknn net23 VPW nm1p2_svt_lp W=230n L=60n MR=1
MNM5 net40 net23 VSS VPW nm1p2_svt_lp W=150e-9 L=60e-9 MR=1
MNM6 net14 cknn net40 VPW nm1p2_svt_lp W=150e-9 L=60e-9 MR=1
MNM4 net23 net14 VSS VPW nm1p2_svt_lp W=470e-9 L=60e-9 MR=1
MNM2 net42 D VSS VPW nm1p2_svt_lp W=470e-9 L=60e-9 MR=1
MNM3 net14 ckb net42 VPW nm1p2_svt_lp W=470e-9 L=60e-9 MR=1
MNM1 ckb cknn VSS VPW nm1p2_svt_lp W=230e-9 L=60e-9 MR=1
MNM0 cknn CKN VSS VPW nm1p2_svt_lp W=230e-9 L=60e-9 MR=1
MPM11 Q net32 VDD VNW pm1p2_svt_lp W=1.18e-6 L=60e-9 MR=1
MPM10 net26 cknn net39 VNW pm1p2_svt_lp W=150e-9 L=60e-9 MR=1
MPM9 net39 net32 VDD VNW pm1p2_svt_lp W=150e-9 L=60e-9 MR=1
MPM8 net32 net26 VDD VNW pm1p2_svt_lp W=590e-9 L=60e-9 MR=1
MPM7 net26 ckb net23 VNW pm1p2_svt_lp W=300n L=60n MR=1
MPM6 net14 ckb net41 VNW pm1p2_svt_lp W=150e-9 L=60e-9 MR=1
MPM5 net41 net23 VDD VNW pm1p2_svt_lp W=150e-9 L=60e-9 MR=1
MPM4 net23 net14 VDD VNW pm1p2_svt_lp W=590e-9 L=60e-9 MR=1
MPM3 net14 cknn net43 VNW pm1p2_svt_lp W=590e-9 L=60e-9 MR=1
MPM2 net43 D VDD VNW pm1p2_svt_lp W=590e-9 L=60e-9 MR=1
MPM1 ckb cknn VDD VNW pm1p2_svt_lp W=300e-9 L=60e-9 MR=1
MPM0 cknn CKN VDD VNW pm1p2_svt_lp W=300e-9 L=60e-9 MR=1
.ENDS
.SUBCKT DFFNQX4_9TSVT CKN D Q VDD VSS VNW VPW
MNM11 Q net32 VSS VPW nm1p2_svt_lp W=1.88e-6 L=60e-9 MR=1
MNM9 net38 net32 VSS VPW nm1p2_svt_lp W=150e-9 L=60e-9 MR=1
MNM10 net26 ckb net38 VPW nm1p2_svt_lp W=150e-9 L=60e-9 MR=1
MNM8 net32 net26 VSS VPW nm1p2_svt_lp W=940e-9 L=60e-9 MR=1
MNM7 net26 cknn net23 VPW nm1p2_svt_lp W=230n L=60n MR=1
MNM5 net40 net23 VSS VPW nm1p2_svt_lp W=150e-9 L=60e-9 MR=1
MNM6 net14 cknn net40 VPW nm1p2_svt_lp W=150e-9 L=60e-9 MR=1
MNM4 net23 net14 VSS VPW nm1p2_svt_lp W=470e-9 L=60e-9 MR=1
MNM2 net42 D VSS VPW nm1p2_svt_lp W=470e-9 L=60e-9 MR=1
MNM3 net14 ckb net42 VPW nm1p2_svt_lp W=470e-9 L=60e-9 MR=1
MNM1 ckb cknn VSS VPW nm1p2_svt_lp W=230n L=60n MR=1
MNM0 cknn CKN VSS VPW nm1p2_svt_lp W=230n L=60n MR=1
MPM11 Q net32 VDD VNW pm1p2_svt_lp W=2.36e-6 L=60e-9 MR=1
MPM10 net26 cknn net39 VNW pm1p2_svt_lp W=150e-9 L=60e-9 MR=1
MPM9 net39 net32 VDD VNW pm1p2_svt_lp W=150e-9 L=60e-9 MR=1
MPM8 net32 net26 VDD VNW pm1p2_svt_lp W=1.18e-6 L=60e-9 MR=1
MPM7 net26 ckb net23 VNW pm1p2_svt_lp W=300n L=60n MR=1
MPM6 net14 ckb net41 VNW pm1p2_svt_lp W=150e-9 L=60e-9 MR=1
MPM5 net41 net23 VDD VNW pm1p2_svt_lp W=150e-9 L=60e-9 MR=1
MPM4 net23 net14 VDD VNW pm1p2_svt_lp W=590e-9 L=60e-9 MR=1
MPM3 net14 cknn net43 VNW pm1p2_svt_lp W=590e-9 L=60e-9 MR=1
MPM2 net43 D VDD VNW pm1p2_svt_lp W=590e-9 L=60e-9 MR=1
MPM1 ckb cknn VDD VNW pm1p2_svt_lp W=300n L=60n MR=1
MPM0 cknn CKN VDD VNW pm1p2_svt_lp W=300n L=60n MR=1
.ENDS
.SUBCKT DFFNRNQX0P5_9TSVT CKN D Q RN VDD VSS VNW VPW
MNM11 Q net31 VSS VPW nm1p2_svt_lp W=230e-9 L=60e-9 MR=1
MNM9 net43 net31 VSS VPW nm1p2_svt_lp W=150e-9 L=60e-9 MR=1
MNM10 net28 ckb net43 VPW nm1p2_svt_lp W=150e-9 L=60e-9 MR=1
MNM_RN2 net45 RN VSS VPW nm1p2_svt_lp W=230e-9 L=60e-9 MR=1
MNM8 net31 net28 net45 VPW nm1p2_svt_lp W=230e-9 L=60e-9 MR=1
MNM7 net28 cknn net25 VPW nm1p2_svt_lp W=230e-9 L=60e-9 MR=1
MNM_RN net46 RN VSS VPW nm1p2_svt_lp W=150e-9 L=60e-9 MR=1
MNM5 net47 net25 net46 VPW nm1p2_svt_lp W=150e-9 L=60e-9 MR=1
MNM6 net16 cknn net47 VPW nm1p2_svt_lp W=150e-9 L=60e-9 MR=1
MNM4 net25 net16 VSS VPW nm1p2_svt_lp W=230e-9 L=60e-9 MR=1
MNM2 net48 D VSS VPW nm1p2_svt_lp W=230e-9 L=60e-9 MR=1
MNM3 net16 ckb net48 VPW nm1p2_svt_lp W=230e-9 L=60e-9 MR=1
MNM1 ckb cknn VSS VPW nm1p2_svt_lp W=230e-9 L=60e-9 MR=1
MNM0 cknn CKN VSS VPW nm1p2_svt_lp W=230e-9 L=60e-9 MR=1
MPM11 Q net31 VDD VNW pm1p2_svt_lp W=300e-9 L=60e-9 MR=1
MPM10 net28 cknn net44 VNW pm1p2_svt_lp W=150e-9 L=60e-9 MR=1
MPM9 net44 net31 VDD VNW pm1p2_svt_lp W=150e-9 L=60e-9 MR=1
MPM_RN2 net31 RN VDD VNW pm1p2_svt_lp W=300e-9 L=60e-9 MR=1
MPM8 net31 net28 VDD VNW pm1p2_svt_lp W=300e-9 L=60e-9 MR=1
MPM7 net28 ckb net25 VNW pm1p2_svt_lp W=300e-9 L=60e-9 MR=1
MPM6 net16 ckb net38 VNW pm1p2_svt_lp W=150e-9 L=60e-9 MR=1
MPM_RN net38 RN VDD VNW pm1p2_svt_lp W=150e-9 L=60e-9 MR=1
MPM5 net38 net25 VDD VNW pm1p2_svt_lp W=150e-9 L=60e-9 MR=1
MPM4 net25 net16 VDD VNW pm1p2_svt_lp W=300e-9 L=60e-9 MR=1
MPM3 net16 cknn net49 VNW pm1p2_svt_lp W=300e-9 L=60e-9 MR=1
MPM2 net49 D VDD VNW pm1p2_svt_lp W=300e-9 L=60e-9 MR=1
MPM1 ckb cknn VDD VNW pm1p2_svt_lp W=300e-9 L=60e-9 MR=1
MPM0 cknn CKN VDD VNW pm1p2_svt_lp W=300e-9 L=60e-9 MR=1
.ENDS
.SUBCKT DFFNRNQX1_9TSVT CKN D Q RN VDD VSS VNW VPW
MNM11 Q net31 VSS VPW nm1p2_svt_lp W=470e-9 L=60e-9 MR=1
MNM9 net43 net31 VSS VPW nm1p2_svt_lp W=150e-9 L=60e-9 MR=1
MNM10 net28 ckb net43 VPW nm1p2_svt_lp W=150e-9 L=60e-9 MR=1
MNM_RN2 net45 RN VSS VPW nm1p2_svt_lp W=470e-9 L=60e-9 MR=1
MNM8 net31 net28 net45 VPW nm1p2_svt_lp W=470e-9 L=60e-9 MR=1
MNM7 net28 cknn net25 VPW nm1p2_svt_lp W=230n L=60n MR=1
MNM_RN net46 RN VSS VPW nm1p2_svt_lp W=150e-9 L=60e-9 MR=1
MNM5 net47 net25 net46 VPW nm1p2_svt_lp W=150e-9 L=60e-9 MR=1
MNM6 net16 cknn net47 VPW nm1p2_svt_lp W=150e-9 L=60e-9 MR=1
MNM4 net25 net16 VSS VPW nm1p2_svt_lp W=340e-9 L=60e-9 MR=1
MNM2 net48 D VSS VPW nm1p2_svt_lp W=230n L=60n MR=1
MNM3 net16 ckb net48 VPW nm1p2_svt_lp W=230n L=60n MR=1
MNM1 ckb cknn VSS VPW nm1p2_svt_lp W=230e-9 L=60e-9 MR=1
MNM0 cknn CKN VSS VPW nm1p2_svt_lp W=230e-9 L=60e-9 MR=1
MPM11 Q net31 VDD VNW pm1p2_svt_lp W=590e-9 L=60e-9 MR=1
MPM10 net28 cknn net44 VNW pm1p2_svt_lp W=150e-9 L=60e-9 MR=1
MPM9 net44 net31 VDD VNW pm1p2_svt_lp W=150e-9 L=60e-9 MR=1
MPM_RN2 net31 RN VDD VNW pm1p2_svt_lp W=590e-9 L=60e-9 MR=1
MPM8 net31 net28 VDD VNW pm1p2_svt_lp W=590e-9 L=60e-9 MR=1
MPM7 net28 ckb net25 VNW pm1p2_svt_lp W=300n L=60n MR=1
MPM6 net16 ckb net38 VNW pm1p2_svt_lp W=150e-9 L=60e-9 MR=1
MPM_RN net38 RN VDD VNW pm1p2_svt_lp W=150e-9 L=60e-9 MR=1
MPM5 net38 net25 VDD VNW pm1p2_svt_lp W=150e-9 L=60e-9 MR=1
MPM4 net25 net16 VDD VNW pm1p2_svt_lp W=360e-9 L=60e-9 MR=1
MPM3 net16 cknn net49 VNW pm1p2_svt_lp W=300n L=60n MR=1
MPM2 net49 D VDD VNW pm1p2_svt_lp W=300n L=60n MR=1
MPM1 ckb cknn VDD VNW pm1p2_svt_lp W=300e-9 L=60e-9 MR=1
MPM0 cknn CKN VDD VNW pm1p2_svt_lp W=300e-9 L=60e-9 MR=1
.ENDS
.SUBCKT DFFNRNQX2_9TSVT CKN D Q RN VDD VSS VNW VPW
MNM11 Q net31 VSS VPW nm1p2_svt_lp W=940e-9 L=60e-9 MR=1
MNM9 net43 net31 VSS VPW nm1p2_svt_lp W=150e-9 L=60e-9 MR=1
MNM10 net28 ckb net43 VPW nm1p2_svt_lp W=150e-9 L=60e-9 MR=1
MNM_RN2 net45 RN VSS VPW nm1p2_svt_lp W=470e-9 L=60e-9 MR=1
MNM8 net31 net28 net45 VPW nm1p2_svt_lp W=470e-9 L=60e-9 MR=1
MNM7 net28 cknn net25 VPW nm1p2_svt_lp W=230n L=60n MR=1
MNM_RN net46 RN VSS VPW nm1p2_svt_lp W=150e-9 L=60e-9 MR=1
MNM5 net47 net25 net46 VPW nm1p2_svt_lp W=150e-9 L=60e-9 MR=1
MNM6 net16 cknn net47 VPW nm1p2_svt_lp W=150e-9 L=60e-9 MR=1
MNM4 net25 net16 VSS VPW nm1p2_svt_lp W=340e-9 L=60e-9 MR=1
MNM2 net48 D VSS VPW nm1p2_svt_lp W=470e-9 L=60e-9 MR=1
MNM3 net16 ckb net48 VPW nm1p2_svt_lp W=470e-9 L=60e-9 MR=1
MNM1 ckb cknn VSS VPW nm1p2_svt_lp W=230e-9 L=60e-9 MR=1
MNM0 cknn CKN VSS VPW nm1p2_svt_lp W=230e-9 L=60e-9 MR=1
MPM11 Q net31 VDD VNW pm1p2_svt_lp W=1.18e-6 L=60e-9 MR=1
MPM10 net28 cknn net44 VNW pm1p2_svt_lp W=150e-9 L=60e-9 MR=1
MPM9 net44 net31 VDD VNW pm1p2_svt_lp W=150e-9 L=60e-9 MR=1
MPM_RN2 net31 RN VDD VNW pm1p2_svt_lp W=590e-9 L=60e-9 MR=1
MPM8 net31 net28 VDD VNW pm1p2_svt_lp W=590e-9 L=60e-9 MR=1
MPM7 net28 ckb net25 VNW pm1p2_svt_lp W=300n L=60n MR=1
MPM6 net16 ckb net38 VNW pm1p2_svt_lp W=150e-9 L=60e-9 MR=1
MPM_RN net38 RN VDD VNW pm1p2_svt_lp W=150e-9 L=60e-9 MR=1
MPM5 net38 net25 VDD VNW pm1p2_svt_lp W=150e-9 L=60e-9 MR=1
MPM4 net25 net16 VDD VNW pm1p2_svt_lp W=360e-9 L=60e-9 MR=1
MPM3 net16 cknn net49 VNW pm1p2_svt_lp W=590e-9 L=60e-9 MR=1
MPM2 net49 D VDD VNW pm1p2_svt_lp W=590e-9 L=60e-9 MR=1
MPM1 ckb cknn VDD VNW pm1p2_svt_lp W=300e-9 L=60e-9 MR=1
MPM0 cknn CKN VDD VNW pm1p2_svt_lp W=300e-9 L=60e-9 MR=1
.ENDS
.SUBCKT DFFNRNQX4_9TSVT CKN D Q RN VDD VSS VNW VPW
MNM11 Q net31 VSS VPW nm1p2_svt_lp W=1.88e-6 L=60e-9 MR=1
MNM9 net43 net31 VSS VPW nm1p2_svt_lp W=150e-9 L=60e-9 MR=1
MNM10 net28 ckb net43 VPW nm1p2_svt_lp W=150e-9 L=60e-9 MR=1
MNM_RN2 net45 RN VSS VPW nm1p2_svt_lp W=940e-9 L=60e-9 MR=1
MNM8 net31 net28 net45 VPW nm1p2_svt_lp W=940e-9 L=60e-9 MR=1
MNM7 net28 cknn net25 VPW nm1p2_svt_lp W=230n L=60n MR=1
MNM_RN net46 RN VSS VPW nm1p2_svt_lp W=150e-9 L=60e-9 MR=1
MNM5 net47 net25 net46 VPW nm1p2_svt_lp W=150e-9 L=60e-9 MR=1
MNM6 net16 cknn net47 VPW nm1p2_svt_lp W=150e-9 L=60e-9 MR=1
MNM4 net25 net16 VSS VPW nm1p2_svt_lp W=340e-9 L=60e-9 MR=1
MNM2 net48 D VSS VPW nm1p2_svt_lp W=470e-9 L=60e-9 MR=1
MNM3 net16 ckb net48 VPW nm1p2_svt_lp W=470e-9 L=60e-9 MR=1
MNM1 ckb cknn VSS VPW nm1p2_svt_lp W=230n L=60n MR=1
MNM0 cknn CKN VSS VPW nm1p2_svt_lp W=230n L=60n MR=1
MPM11 Q net31 VDD VNW pm1p2_svt_lp W=2.36e-6 L=60e-9 MR=1
MPM10 net28 cknn net44 VNW pm1p2_svt_lp W=150e-9 L=60e-9 MR=1
MPM9 net44 net31 VDD VNW pm1p2_svt_lp W=150e-9 L=60e-9 MR=1
MPM_RN2 net31 RN VDD VNW pm1p2_svt_lp W=1.18e-6 L=60e-9 MR=1
MPM8 net31 net28 VDD VNW pm1p2_svt_lp W=1.18e-6 L=60e-9 MR=1
MPM7 net28 ckb net25 VNW pm1p2_svt_lp W=300n L=60n MR=1
MPM6 net16 ckb net38 VNW pm1p2_svt_lp W=150e-9 L=60e-9 MR=1
MPM_RN net38 RN VDD VNW pm1p2_svt_lp W=150e-9 L=60e-9 MR=1
MPM5 net38 net25 VDD VNW pm1p2_svt_lp W=150e-9 L=60e-9 MR=1
MPM4 net25 net16 VDD VNW pm1p2_svt_lp W=360e-9 L=60e-9 MR=1
MPM3 net16 cknn net49 VNW pm1p2_svt_lp W=590e-9 L=60e-9 MR=1
MPM2 net49 D VDD VNW pm1p2_svt_lp W=590e-9 L=60e-9 MR=1
MPM1 ckb cknn VDD VNW pm1p2_svt_lp W=300n L=60n MR=1
MPM0 cknn CKN VDD VNW pm1p2_svt_lp W=300n L=60n MR=1
.ENDS
.SUBCKT DFFNRSNQX0P5_9TSVT CKN D Q RN SN VDD VSS VNW VPW
MNM11 Q net32 VSS VPW nm1p2_svt_lp W=230e-9 L=60e-9 MR=1
MNM9 net48 net32 VSS VPW nm1p2_svt_lp W=150e-9 L=60e-9 MR=1
MNM_SN2 net49 SN net48 VPW nm1p2_svt_lp W=150e-9 L=60e-9 MR=1
MNM10 net29 ckb net49 VPW nm1p2_svt_lp W=150e-9 L=60e-9 MR=1
MNM_RN2 net50 RN VSS VPW nm1p2_svt_lp W=230e-9 L=60e-9 MR=1
MNM8 net32 net29 net50 VPW nm1p2_svt_lp W=230e-9 L=60e-9 MR=1
MNM7 net29 cknn net24 VPW nm1p2_svt_lp W=230e-9 L=60e-9 MR=1
MNM_RN net51 RN VSS VPW nm1p2_svt_lp W=150e-9 L=60e-9 MR=1
MNM5 net52 net24 net51 VPW nm1p2_svt_lp W=150e-9 L=60e-9 MR=1
MNM6 net18 cknn net52 VPW nm1p2_svt_lp W=150e-9 L=60e-9 MR=1
MNM4 net53 net18 VSS VPW nm1p2_svt_lp W=230e-9 L=60e-9 MR=1
MNM_SN net24 SN net53 VPW nm1p2_svt_lp W=230e-9 L=60e-9 MR=1
MNM2 net54 D VSS VPW nm1p2_svt_lp W=230e-9 L=60e-9 MR=1
MNM3 net18 ckb net54 VPW nm1p2_svt_lp W=230e-9 L=60e-9 MR=1
MNM1 ckb cknn VSS VPW nm1p2_svt_lp W=230e-9 L=60e-9 MR=1
MNM0 cknn CKN VSS VPW nm1p2_svt_lp W=230e-9 L=60e-9 MR=1
MPM11 Q net32 VDD VNW pm1p2_svt_lp W=300e-9 L=60e-9 MR=1
MPM10 net29 cknn net46 VNW pm1p2_svt_lp W=150e-9 L=60e-9 MR=1
MPM_SN2 net46 SN VDD VNW pm1p2_svt_lp W=150e-9 L=60e-9 MR=1
MPM9 net46 net32 VDD VNW pm1p2_svt_lp W=150e-9 L=60e-9 MR=1
MPM_RN2 net32 RN VDD VNW pm1p2_svt_lp W=300e-9 L=60e-9 MR=1
MPM8 net32 net29 VDD VNW pm1p2_svt_lp W=300e-9 L=60e-9 MR=1
MPM7 net29 ckb net24 VNW pm1p2_svt_lp W=300e-9 L=60e-9 MR=1
MPM6 net18 ckb net41 VNW pm1p2_svt_lp W=150e-9 L=60e-9 MR=1
MPM_RN net41 RN VDD VNW pm1p2_svt_lp W=150e-9 L=60e-9 MR=1
MPM5 net41 net24 VDD VNW pm1p2_svt_lp W=150e-9 L=60e-9 MR=1
MPM_SN net24 SN VDD VNW pm1p2_svt_lp W=300e-9 L=60e-9 MR=1
MPM4 net24 net18 VDD VNW pm1p2_svt_lp W=300e-9 L=60e-9 MR=1
MPM3 net18 cknn net55 VNW pm1p2_svt_lp W=300e-9 L=60e-9 MR=1
MPM2 net55 D VDD VNW pm1p2_svt_lp W=300e-9 L=60e-9 MR=1
MPM1 ckb cknn VDD VNW pm1p2_svt_lp W=300e-9 L=60e-9 MR=1
MPM0 cknn CKN VDD VNW pm1p2_svt_lp W=300e-9 L=60e-9 MR=1
.ENDS
.SUBCKT DFFNRSNQX1_9TSVT CKN D Q RN SN VDD VSS VNW VPW
MNM11 Q net32 VSS VPW nm1p2_svt_lp W=470e-9 L=60e-9 MR=1
MNM9 net48 net32 VSS VPW nm1p2_svt_lp W=150e-9 L=60e-9 MR=1
MNM_SN2 net49 SN net48 VPW nm1p2_svt_lp W=150e-9 L=60e-9 MR=1
MNM10 net29 ckb net49 VPW nm1p2_svt_lp W=150e-9 L=60e-9 MR=1
MNM_RN2 net50 RN VSS VPW nm1p2_svt_lp W=470e-9 L=60e-9 MR=1
MNM8 net32 net29 net50 VPW nm1p2_svt_lp W=470e-9 L=60e-9 MR=1
MNM7 net29 cknn net24 VPW nm1p2_svt_lp W=230n L=60n MR=1
MNM_RN net51 RN VSS VPW nm1p2_svt_lp W=150e-9 L=60e-9 MR=1
MNM5 net52 net24 net51 VPW nm1p2_svt_lp W=150e-9 L=60e-9 MR=1
MNM6 net18 cknn net52 VPW nm1p2_svt_lp W=150e-9 L=60e-9 MR=1
MNM4 net53 net18 VSS VPW nm1p2_svt_lp W=470e-9 L=60e-9 MR=1
MNM_SN net24 SN net53 VPW nm1p2_svt_lp W=470e-9 L=60e-9 MR=1
MNM2 net54 D VSS VPW nm1p2_svt_lp W=230n L=60n MR=1
MNM3 net18 ckb net54 VPW nm1p2_svt_lp W=230n L=60n MR=1
MNM1 ckb cknn VSS VPW nm1p2_svt_lp W=230e-9 L=60e-9 MR=1
MNM0 cknn CKN VSS VPW nm1p2_svt_lp W=230e-9 L=60e-9 MR=1
MPM11 Q net32 VDD VNW pm1p2_svt_lp W=590e-9 L=60e-9 MR=1
MPM10 net29 cknn net46 VNW pm1p2_svt_lp W=150e-9 L=60e-9 MR=1
MPM_SN2 net46 SN VDD VNW pm1p2_svt_lp W=150e-9 L=60e-9 MR=1
MPM9 net46 net32 VDD VNW pm1p2_svt_lp W=150e-9 L=60e-9 MR=1
MPM_RN2 net32 RN VDD VNW pm1p2_svt_lp W=590e-9 L=60e-9 MR=1
MPM8 net32 net29 VDD VNW pm1p2_svt_lp W=590e-9 L=60e-9 MR=1
MPM7 net29 ckb net24 VNW pm1p2_svt_lp W=300n L=60n MR=1
MPM6 net18 ckb net41 VNW pm1p2_svt_lp W=150e-9 L=60e-9 MR=1
MPM_RN net41 RN VDD VNW pm1p2_svt_lp W=150e-9 L=60e-9 MR=1
MPM5 net41 net24 VDD VNW pm1p2_svt_lp W=150e-9 L=60e-9 MR=1
MPM_SN net24 SN VDD VNW pm1p2_svt_lp W=370e-9 L=60e-9 MR=1
MPM4 net24 net18 VDD VNW pm1p2_svt_lp W=390e-9 L=60e-9 MR=1
MPM3 net18 cknn net55 VNW pm1p2_svt_lp W=300n L=60n MR=1
MPM2 net55 D VDD VNW pm1p2_svt_lp W=300n L=60n MR=1
MPM1 ckb cknn VDD VNW pm1p2_svt_lp W=300e-9 L=60e-9 MR=1
MPM0 cknn CKN VDD VNW pm1p2_svt_lp W=300e-9 L=60e-9 MR=1
.ENDS
.SUBCKT DFFNRSNQX2_9TSVT CKN D Q RN SN VDD VSS VNW VPW
MNM11 Q net32 VSS VPW nm1p2_svt_lp W=940e-9 L=60e-9 MR=1
MNM9 net48 net32 VSS VPW nm1p2_svt_lp W=150e-9 L=60e-9 MR=1
MNM_SN2 net49 SN net48 VPW nm1p2_svt_lp W=150e-9 L=60e-9 MR=1
MNM10 net29 ckb net49 VPW nm1p2_svt_lp W=150e-9 L=60e-9 MR=1
MNM_RN2 net50 RN VSS VPW nm1p2_svt_lp W=470e-9 L=60e-9 MR=1
MNM8 net32 net29 net50 VPW nm1p2_svt_lp W=470e-9 L=60e-9 MR=1
MNM7 net29 cknn net24 VPW nm1p2_svt_lp W=230n L=60n MR=1
MNM_RN net51 RN VSS VPW nm1p2_svt_lp W=150e-9 L=60e-9 MR=1
MNM5 net52 net24 net51 VPW nm1p2_svt_lp W=150e-9 L=60e-9 MR=1
MNM6 net18 cknn net52 VPW nm1p2_svt_lp W=150e-9 L=60e-9 MR=1
MNM4 net53 net18 VSS VPW nm1p2_svt_lp W=470e-9 L=60e-9 MR=1
MNM_SN net24 SN net53 VPW nm1p2_svt_lp W=470e-9 L=60e-9 MR=1
MNM2 net54 D VSS VPW nm1p2_svt_lp W=470e-9 L=60e-9 MR=1
MNM3 net18 ckb net54 VPW nm1p2_svt_lp W=470e-9 L=60e-9 MR=1
MNM1 ckb cknn VSS VPW nm1p2_svt_lp W=230e-9 L=60e-9 MR=1
MNM0 cknn CKN VSS VPW nm1p2_svt_lp W=230e-9 L=60e-9 MR=1
MPM11 Q net32 VDD VNW pm1p2_svt_lp W=1.18e-6 L=60e-9 MR=1
MPM10 net29 cknn net46 VNW pm1p2_svt_lp W=150e-9 L=60e-9 MR=1
MPM_SN2 net46 SN VDD VNW pm1p2_svt_lp W=150e-9 L=60e-9 MR=1
MPM9 net46 net32 VDD VNW pm1p2_svt_lp W=150e-9 L=60e-9 MR=1
MPM_RN2 net32 RN VDD VNW pm1p2_svt_lp W=590e-9 L=60e-9 MR=1
MPM8 net32 net29 VDD VNW pm1p2_svt_lp W=590e-9 L=60e-9 MR=1
MPM7 net29 ckb net24 VNW pm1p2_svt_lp W=300n L=60n MR=1
MPM6 net18 ckb net41 VNW pm1p2_svt_lp W=150e-9 L=60e-9 MR=1
MPM_RN net41 RN VDD VNW pm1p2_svt_lp W=150e-9 L=60e-9 MR=1
MPM5 net41 net24 VDD VNW pm1p2_svt_lp W=150e-9 L=60e-9 MR=1
MPM_SN net24 SN VDD VNW pm1p2_svt_lp W=370e-9 L=60e-9 MR=1
MPM4 net24 net18 VDD VNW pm1p2_svt_lp W=390e-9 L=60e-9 MR=1
MPM3 net18 cknn net55 VNW pm1p2_svt_lp W=590e-9 L=60e-9 MR=1
MPM2 net55 D VDD VNW pm1p2_svt_lp W=590e-9 L=60e-9 MR=1
MPM1 ckb cknn VDD VNW pm1p2_svt_lp W=300e-9 L=60e-9 MR=1
MPM0 cknn CKN VDD VNW pm1p2_svt_lp W=300e-9 L=60e-9 MR=1
.ENDS
.SUBCKT DFFNRSNQX4_9TSVT CKN D Q RN SN VDD VSS VNW VPW
MNM11 Q net32 VSS VPW nm1p2_svt_lp W=1.88e-6 L=60e-9 MR=1
MNM9 net48 net32 VSS VPW nm1p2_svt_lp W=150e-9 L=60e-9 MR=1
MNM_SN2 net49 SN net48 VPW nm1p2_svt_lp W=150e-9 L=60e-9 MR=1
MNM10 net29 ckb net49 VPW nm1p2_svt_lp W=150e-9 L=60e-9 MR=1
MNM_RN2 net50 RN VSS VPW nm1p2_svt_lp W=940e-9 L=60e-9 MR=1
MNM8 net32 net29 net50 VPW nm1p2_svt_lp W=940e-9 L=60e-9 MR=1
MNM7 net29 cknn net24 VPW nm1p2_svt_lp W=230n L=60n MR=1
MNM_RN net51 RN VSS VPW nm1p2_svt_lp W=150e-9 L=60e-9 MR=1
MNM5 net52 net24 net51 VPW nm1p2_svt_lp W=150e-9 L=60e-9 MR=1
MNM6 net18 cknn net52 VPW nm1p2_svt_lp W=150e-9 L=60e-9 MR=1
MNM4 net53 net18 VSS VPW nm1p2_svt_lp W=470e-9 L=60e-9 MR=1
MNM_SN net24 SN net53 VPW nm1p2_svt_lp W=470e-9 L=60e-9 MR=1
MNM2 net54 D VSS VPW nm1p2_svt_lp W=470e-9 L=60e-9 MR=1
MNM3 net18 ckb net54 VPW nm1p2_svt_lp W=470e-9 L=60e-9 MR=1
MNM1 ckb cknn VSS VPW nm1p2_svt_lp W=230n L=60n MR=1
MNM0 cknn CKN VSS VPW nm1p2_svt_lp W=230n L=60n MR=1
MPM11 Q net32 VDD VNW pm1p2_svt_lp W=2.36e-6 L=60e-9 MR=1
MPM10 net29 cknn net46 VNW pm1p2_svt_lp W=150e-9 L=60e-9 MR=1
MPM_SN2 net46 SN VDD VNW pm1p2_svt_lp W=150e-9 L=60e-9 MR=1
MPM9 net46 net32 VDD VNW pm1p2_svt_lp W=150e-9 L=60e-9 MR=1
MPM_RN2 net32 RN VDD VNW pm1p2_svt_lp W=1.18e-6 L=60e-9 MR=1
MPM8 net32 net29 VDD VNW pm1p2_svt_lp W=1.18e-6 L=60e-9 MR=1
MPM7 net29 ckb net24 VNW pm1p2_svt_lp W=300n L=60n MR=1
MPM6 net18 ckb net41 VNW pm1p2_svt_lp W=150e-9 L=60e-9 MR=1
MPM_RN net41 RN VDD VNW pm1p2_svt_lp W=150e-9 L=60e-9 MR=1
MPM5 net41 net24 VDD VNW pm1p2_svt_lp W=150e-9 L=60e-9 MR=1
MPM_SN net24 SN VDD VNW pm1p2_svt_lp W=370e-9 L=60e-9 MR=1
MPM4 net24 net18 VDD VNW pm1p2_svt_lp W=390e-9 L=60e-9 MR=1
MPM3 net18 cknn net55 VNW pm1p2_svt_lp W=590e-9 L=60e-9 MR=1
MPM2 net55 D VDD VNW pm1p2_svt_lp W=590e-9 L=60e-9 MR=1
MPM1 ckb cknn VDD VNW pm1p2_svt_lp W=300n L=60n MR=1
MPM0 cknn CKN VDD VNW pm1p2_svt_lp W=300n L=60n MR=1
.ENDS
.SUBCKT DFFNSNQX0P5_9TSVT CKN D Q SN VDD VSS VNW VPW
MNM11 Q net33 VSS VPW nm1p2_svt_lp W=230e-9 L=60e-9 MR=1
MNM9 net43 net33 VSS VPW nm1p2_svt_lp W=150e-9 L=60e-9 MR=1
MNM_SN2 net44 SN net43 VPW nm1p2_svt_lp W=150e-9 L=60e-9 MR=1
MNM10 net27 ckb net44 VPW nm1p2_svt_lp W=150e-9 L=60e-9 MR=1
MNM8 net33 net27 VSS VPW nm1p2_svt_lp W=230e-9 L=60e-9 MR=1
MNM7 net27 cknn net22 VPW nm1p2_svt_lp W=230e-9 L=60e-9 MR=1
MNM5 net45 net22 VSS VPW nm1p2_svt_lp W=150e-9 L=60e-9 MR=1
MNM6 net16 cknn net45 VPW nm1p2_svt_lp W=150e-9 L=60e-9 MR=1
MNM4 net47 net16 VSS VPW nm1p2_svt_lp W=230e-9 L=60e-9 MR=1
MNM_SN net22 SN net47 VPW nm1p2_svt_lp W=230e-9 L=60e-9 MR=1
MNM2 net48 D VSS VPW nm1p2_svt_lp W=230e-9 L=60e-9 MR=1
MNM3 net16 ckb net48 VPW nm1p2_svt_lp W=230e-9 L=60e-9 MR=1
MNM1 ckb cknn VSS VPW nm1p2_svt_lp W=230e-9 L=60e-9 MR=1
MNM0 cknn CKN VSS VPW nm1p2_svt_lp W=230e-9 L=60e-9 MR=1
MPM11 Q net33 VDD VNW pm1p2_svt_lp W=300e-9 L=60e-9 MR=1
MPM10 net27 cknn net41 VNW pm1p2_svt_lp W=150e-9 L=60e-9 MR=1
MPM_SN2 net41 SN VDD VNW pm1p2_svt_lp W=150e-9 L=60e-9 MR=1
MPM9 net41 net33 VDD VNW pm1p2_svt_lp W=150e-9 L=60e-9 MR=1
MPM8 net33 net27 VDD VNW pm1p2_svt_lp W=300e-9 L=60e-9 MR=1
MPM7 net27 ckb net22 VNW pm1p2_svt_lp W=300e-9 L=60e-9 MR=1
MPM6 net16 ckb net46 VNW pm1p2_svt_lp W=150e-9 L=60e-9 MR=1
MPM5 net46 net22 VDD VNW pm1p2_svt_lp W=150e-9 L=60e-9 MR=1
MPM_SN net22 SN VDD VNW pm1p2_svt_lp W=300e-9 L=60e-9 MR=1
MPM4 net22 net16 VDD VNW pm1p2_svt_lp W=300e-9 L=60e-9 MR=1
MPM3 net16 cknn net49 VNW pm1p2_svt_lp W=300e-9 L=60e-9 MR=1
MPM2 net49 D VDD VNW pm1p2_svt_lp W=300e-9 L=60e-9 MR=1
MPM1 ckb cknn VDD VNW pm1p2_svt_lp W=300e-9 L=60e-9 MR=1
MPM0 cknn CKN VDD VNW pm1p2_svt_lp W=300e-9 L=60e-9 MR=1
.ENDS
.SUBCKT DFFNSNQX1_9TSVT CKN D Q SN VDD VSS VNW VPW
MNM11 Q net33 VSS VPW nm1p2_svt_lp W=470e-9 L=60e-9 MR=1
MNM9 net43 net33 VSS VPW nm1p2_svt_lp W=150e-9 L=60e-9 MR=1
MNM_SN2 net44 SN net43 VPW nm1p2_svt_lp W=150e-9 L=60e-9 MR=1
MNM10 net27 ckb net44 VPW nm1p2_svt_lp W=150e-9 L=60e-9 MR=1
MNM8 net33 net27 VSS VPW nm1p2_svt_lp W=470e-9 L=60e-9 MR=1
MNM7 net27 cknn net22 VPW nm1p2_svt_lp W=230n L=60n MR=1
MNM5 net45 net22 VSS VPW nm1p2_svt_lp W=150e-9 L=60e-9 MR=1
MNM6 net16 cknn net45 VPW nm1p2_svt_lp W=150e-9 L=60e-9 MR=1
MNM4 net47 net16 VSS VPW nm1p2_svt_lp W=470e-9 L=60e-9 MR=1
MNM_SN net22 SN net47 VPW nm1p2_svt_lp W=470e-9 L=60e-9 MR=1
MNM2 net48 D VSS VPW nm1p2_svt_lp W=230n L=60n MR=1
MNM3 net16 ckb net48 VPW nm1p2_svt_lp W=230n L=60n MR=1
MNM1 ckb cknn VSS VPW nm1p2_svt_lp W=230e-9 L=60e-9 MR=1
MNM0 cknn CKN VSS VPW nm1p2_svt_lp W=230e-9 L=60e-9 MR=1
MPM11 Q net33 VDD VNW pm1p2_svt_lp W=590e-9 L=60e-9 MR=1
MPM10 net27 cknn net41 VNW pm1p2_svt_lp W=150e-9 L=60e-9 MR=1
MPM_SN2 net41 SN VDD VNW pm1p2_svt_lp W=150e-9 L=60e-9 MR=1
MPM9 net41 net33 VDD VNW pm1p2_svt_lp W=150e-9 L=60e-9 MR=1
MPM8 net33 net27 VDD VNW pm1p2_svt_lp W=590e-9 L=60e-9 MR=1
MPM7 net27 ckb net22 VNW pm1p2_svt_lp W=300n L=60n MR=1
MPM6 net16 ckb net46 VNW pm1p2_svt_lp W=150e-9 L=60e-9 MR=1
MPM5 net46 net22 VDD VNW pm1p2_svt_lp W=150e-9 L=60e-9 MR=1
MPM_SN net22 SN VDD VNW pm1p2_svt_lp W=590e-9 L=60e-9 MR=1
MPM4 net22 net16 VDD VNW pm1p2_svt_lp W=590e-9 L=60e-9 MR=1
MPM3 net16 cknn net49 VNW pm1p2_svt_lp W=300n L=60n MR=1
MPM2 net49 D VDD VNW pm1p2_svt_lp W=300n L=60n MR=1
MPM1 ckb cknn VDD VNW pm1p2_svt_lp W=300e-9 L=60e-9 MR=1
MPM0 cknn CKN VDD VNW pm1p2_svt_lp W=300e-9 L=60e-9 MR=1
.ENDS
.SUBCKT DFFNSNQX2_9TSVT CKN D Q SN VDD VSS VNW VPW
MNM11 Q net33 VSS VPW nm1p2_svt_lp W=940e-9 L=60e-9 MR=1
MNM9 net43 net33 VSS VPW nm1p2_svt_lp W=150e-9 L=60e-9 MR=1
MNM_SN2 net44 SN net43 VPW nm1p2_svt_lp W=150e-9 L=60e-9 MR=1
MNM10 net27 ckb net44 VPW nm1p2_svt_lp W=150e-9 L=60e-9 MR=1
MNM8 net33 net27 VSS VPW nm1p2_svt_lp W=470e-9 L=60e-9 MR=1
MNM7 net27 cknn net22 VPW nm1p2_svt_lp W=230n L=60n MR=1
MNM5 net45 net22 VSS VPW nm1p2_svt_lp W=150e-9 L=60e-9 MR=1
MNM6 net16 cknn net45 VPW nm1p2_svt_lp W=150e-9 L=60e-9 MR=1
MNM4 net47 net16 VSS VPW nm1p2_svt_lp W=470e-9 L=60e-9 MR=1
MNM_SN net22 SN net47 VPW nm1p2_svt_lp W=470e-9 L=60e-9 MR=1
MNM2 net48 D VSS VPW nm1p2_svt_lp W=470e-9 L=60e-9 MR=1
MNM3 net16 ckb net48 VPW nm1p2_svt_lp W=470e-9 L=60e-9 MR=1
MNM1 ckb cknn VSS VPW nm1p2_svt_lp W=230e-9 L=60e-9 MR=1
MNM0 cknn CKN VSS VPW nm1p2_svt_lp W=230e-9 L=60e-9 MR=1
MPM11 Q net33 VDD VNW pm1p2_svt_lp W=1.18e-6 L=60e-9 MR=1
MPM10 net27 cknn net41 VNW pm1p2_svt_lp W=150e-9 L=60e-9 MR=1
MPM_SN2 net41 SN VDD VNW pm1p2_svt_lp W=150e-9 L=60e-9 MR=1
MPM9 net41 net33 VDD VNW pm1p2_svt_lp W=150e-9 L=60e-9 MR=1
MPM8 net33 net27 VDD VNW pm1p2_svt_lp W=590e-9 L=60e-9 MR=1
MPM7 net27 ckb net22 VNW pm1p2_svt_lp W=300n L=60n MR=1
MPM6 net16 ckb net46 VNW pm1p2_svt_lp W=150e-9 L=60e-9 MR=1
MPM5 net46 net22 VDD VNW pm1p2_svt_lp W=150e-9 L=60e-9 MR=1
MPM_SN net22 SN VDD VNW pm1p2_svt_lp W=590e-9 L=60e-9 MR=1
MPM4 net22 net16 VDD VNW pm1p2_svt_lp W=590e-9 L=60e-9 MR=1
MPM3 net16 cknn net49 VNW pm1p2_svt_lp W=590e-9 L=60e-9 MR=1
MPM2 net49 D VDD VNW pm1p2_svt_lp W=590e-9 L=60e-9 MR=1
MPM1 ckb cknn VDD VNW pm1p2_svt_lp W=300e-9 L=60e-9 MR=1
MPM0 cknn CKN VDD VNW pm1p2_svt_lp W=300e-9 L=60e-9 MR=1
.ENDS
.SUBCKT DFFNSNQX4_9TSVT CKN D Q SN VDD VSS VNW VPW
MNM11 Q net33 VSS VPW nm1p2_svt_lp W=1.88e-6 L=60e-9 MR=1
MNM9 net43 net33 VSS VPW nm1p2_svt_lp W=150e-9 L=60e-9 MR=1
MNM_SN2 net44 SN net43 VPW nm1p2_svt_lp W=150e-9 L=60e-9 MR=1
MNM10 net27 ckb net44 VPW nm1p2_svt_lp W=150e-9 L=60e-9 MR=1
MNM8 net33 net27 VSS VPW nm1p2_svt_lp W=940e-9 L=60e-9 MR=1
MNM7 net27 cknn net22 VPW nm1p2_svt_lp W=230n L=60n MR=1
MNM5 net45 net22 VSS VPW nm1p2_svt_lp W=150e-9 L=60e-9 MR=1
MNM6 net16 cknn net45 VPW nm1p2_svt_lp W=150e-9 L=60e-9 MR=1
MNM4 net47 net16 VSS VPW nm1p2_svt_lp W=470e-9 L=60e-9 MR=1
MNM_SN net22 SN net47 VPW nm1p2_svt_lp W=470e-9 L=60e-9 MR=1
MNM2 net48 D VSS VPW nm1p2_svt_lp W=470e-9 L=60e-9 MR=1
MNM3 net16 ckb net48 VPW nm1p2_svt_lp W=470e-9 L=60e-9 MR=1
MNM1 ckb cknn VSS VPW nm1p2_svt_lp W=230n L=60n MR=1
MNM0 cknn CKN VSS VPW nm1p2_svt_lp W=230n L=60n MR=1
MPM11 Q net33 VDD VNW pm1p2_svt_lp W=2.36e-6 L=60e-9 MR=1
MPM10 net27 cknn net41 VNW pm1p2_svt_lp W=150e-9 L=60e-9 MR=1
MPM_SN2 net41 SN VDD VNW pm1p2_svt_lp W=150e-9 L=60e-9 MR=1
MPM9 net41 net33 VDD VNW pm1p2_svt_lp W=150e-9 L=60e-9 MR=1
MPM8 net33 net27 VDD VNW pm1p2_svt_lp W=1.18e-6 L=60e-9 MR=1
MPM7 net27 ckb net22 VNW pm1p2_svt_lp W=300n L=60n MR=1
MPM6 net16 ckb net46 VNW pm1p2_svt_lp W=150e-9 L=60e-9 MR=1
MPM5 net46 net22 VDD VNW pm1p2_svt_lp W=150e-9 L=60e-9 MR=1
MPM_SN net22 SN VDD VNW pm1p2_svt_lp W=590e-9 L=60e-9 MR=1
MPM4 net22 net16 VDD VNW pm1p2_svt_lp W=590e-9 L=60e-9 MR=1
MPM3 net16 cknn net49 VNW pm1p2_svt_lp W=590e-9 L=60e-9 MR=1
MPM2 net49 D VDD VNW pm1p2_svt_lp W=590e-9 L=60e-9 MR=1
MPM1 ckb cknn VDD VNW pm1p2_svt_lp W=300n L=60n MR=1
MPM0 cknn CKN VDD VNW pm1p2_svt_lp W=300n L=60n MR=1
.ENDS
.SUBCKT DFFQX0P5_9TSVT CK D Q VDD VSS VNW VPW
MNM11 Q net32 VSS VPW nm1p2_svt_lp W=230e-9 L=60e-9 MR=1
MNM9 net38 net32 VSS VPW nm1p2_svt_lp W=150e-9 L=60e-9 MR=1
MNM10 net26 ckn net38 VPW nm1p2_svt_lp W=150e-9 L=60e-9 MR=1
MNM8 net32 net26 VSS VPW nm1p2_svt_lp W=230e-9 L=60e-9 MR=1
MNM7 net26 ckb net23 VPW nm1p2_svt_lp W=230e-9 L=60e-9 MR=1
MNM5 net40 net23 VSS VPW nm1p2_svt_lp W=150e-9 L=60e-9 MR=1
MNM6 net14 ckb net40 VPW nm1p2_svt_lp W=150e-9 L=60e-9 MR=1
MNM4 net23 net14 VSS VPW nm1p2_svt_lp W=230e-9 L=60e-9 MR=1
MNM2 net42 D VSS VPW nm1p2_svt_lp W=230e-9 L=60e-9 MR=1
MNM3 net14 ckn net42 VPW nm1p2_svt_lp W=230e-9 L=60e-9 MR=1
MNM1 ckb ckn VSS VPW nm1p2_svt_lp W=230e-9 L=60e-9 MR=1
MNM0 ckn CK VSS VPW nm1p2_svt_lp W=230e-9 L=60e-9 MR=1
MPM11 Q net32 VDD VNW pm1p2_svt_lp W=300e-9 L=60e-9 MR=1
MPM10 net26 ckb net39 VNW pm1p2_svt_lp W=150e-9 L=60e-9 MR=1
MPM9 net39 net32 VDD VNW pm1p2_svt_lp W=150e-9 L=60e-9 MR=1
MPM8 net32 net26 VDD VNW pm1p2_svt_lp W=300e-9 L=60e-9 MR=1
MPM7 net26 ckn net23 VNW pm1p2_svt_lp W=300e-9 L=60e-9 MR=1
MPM6 net14 ckn net41 VNW pm1p2_svt_lp W=150e-9 L=60e-9 MR=1
MPM5 net41 net23 VDD VNW pm1p2_svt_lp W=150e-9 L=60e-9 MR=1
MPM4 net23 net14 VDD VNW pm1p2_svt_lp W=300e-9 L=60e-9 MR=1
MPM3 net14 ckb net43 VNW pm1p2_svt_lp W=300e-9 L=60e-9 MR=1
MPM2 net43 D VDD VNW pm1p2_svt_lp W=300e-9 L=60e-9 MR=1
MPM1 ckb ckn VDD VNW pm1p2_svt_lp W=300e-9 L=60e-9 MR=1
MPM0 ckn CK VDD VNW pm1p2_svt_lp W=300e-9 L=60e-9 MR=1
.ENDS
.SUBCKT DFFQX1_9TSVT CK D Q VDD VSS VNW VPW
MNM11 Q net32 VSS VPW nm1p2_svt_lp W=470e-9 L=60e-9 MR=1
MNM9 net38 net32 VSS VPW nm1p2_svt_lp W=150e-9 L=60e-9 MR=1
MNM10 net26 ckn net38 VPW nm1p2_svt_lp W=150e-9 L=60e-9 MR=1
MNM8 net32 net26 VSS VPW nm1p2_svt_lp W=470e-9 L=60e-9 MR=1
MNM7 net26 ckb net23 VPW nm1p2_svt_lp W=230n L=60n MR=1
MNM5 net40 net23 VSS VPW nm1p2_svt_lp W=150e-9 L=60e-9 MR=1
MNM6 net14 ckb net40 VPW nm1p2_svt_lp W=150e-9 L=60e-9 MR=1
MNM4 net23 net14 VSS VPW nm1p2_svt_lp W=470e-9 L=60e-9 MR=1
MNM2 net42 D VSS VPW nm1p2_svt_lp W=230n L=60n MR=1
MNM3 net14 ckn net42 VPW nm1p2_svt_lp W=230n L=60n MR=1
MNM1 ckb ckn VSS VPW nm1p2_svt_lp W=230e-9 L=60e-9 MR=1
MNM0 ckn CK VSS VPW nm1p2_svt_lp W=230e-9 L=60e-9 MR=1
MPM11 Q net32 VDD VNW pm1p2_svt_lp W=590e-9 L=60e-9 MR=1
MPM10 net26 ckb net39 VNW pm1p2_svt_lp W=150e-9 L=60e-9 MR=1
MPM9 net39 net32 VDD VNW pm1p2_svt_lp W=150e-9 L=60e-9 MR=1
MPM8 net32 net26 VDD VNW pm1p2_svt_lp W=590e-9 L=60e-9 MR=1
MPM7 net26 ckn net23 VNW pm1p2_svt_lp W=300n L=60n MR=1
MPM6 net14 ckn net41 VNW pm1p2_svt_lp W=150e-9 L=60e-9 MR=1
MPM5 net41 net23 VDD VNW pm1p2_svt_lp W=150e-9 L=60e-9 MR=1
MPM4 net23 net14 VDD VNW pm1p2_svt_lp W=590e-9 L=60e-9 MR=1
MPM3 net14 ckb net43 VNW pm1p2_svt_lp W=300n L=60n MR=1
MPM2 net43 D VDD VNW pm1p2_svt_lp W=300n L=60n MR=1
MPM1 ckb ckn VDD VNW pm1p2_svt_lp W=300e-9 L=60e-9 MR=1
MPM0 ckn CK VDD VNW pm1p2_svt_lp W=300e-9 L=60e-9 MR=1
.ENDS
.SUBCKT DFFQX2_9TSVT CK D Q VDD VSS VNW VPW
MNM11 Q net32 VSS VPW nm1p2_svt_lp W=940e-9 L=60e-9 MR=1
MNM9 net38 net32 VSS VPW nm1p2_svt_lp W=150e-9 L=60e-9 MR=1
MNM10 net26 ckn net38 VPW nm1p2_svt_lp W=150e-9 L=60e-9 MR=1
MNM8 net32 net26 VSS VPW nm1p2_svt_lp W=470e-9 L=60e-9 MR=1
MNM7 net26 ckb net23 VPW nm1p2_svt_lp W=230n L=60n MR=1
MNM5 net40 net23 VSS VPW nm1p2_svt_lp W=150e-9 L=60e-9 MR=1
MNM6 net14 ckb net40 VPW nm1p2_svt_lp W=150e-9 L=60e-9 MR=1
MNM4 net23 net14 VSS VPW nm1p2_svt_lp W=470e-9 L=60e-9 MR=1
MNM2 net42 D VSS VPW nm1p2_svt_lp W=470e-9 L=60e-9 MR=1
MNM3 net14 ckn net42 VPW nm1p2_svt_lp W=470e-9 L=60e-9 MR=1
MNM1 ckb ckn VSS VPW nm1p2_svt_lp W=230e-9 L=60e-9 MR=1
MNM0 ckn CK VSS VPW nm1p2_svt_lp W=230e-9 L=60e-9 MR=1
MPM11 Q net32 VDD VNW pm1p2_svt_lp W=1.18e-6 L=60e-9 MR=1
MPM10 net26 ckb net39 VNW pm1p2_svt_lp W=150e-9 L=60e-9 MR=1
MPM9 net39 net32 VDD VNW pm1p2_svt_lp W=150e-9 L=60e-9 MR=1
MPM8 net32 net26 VDD VNW pm1p2_svt_lp W=590e-9 L=60e-9 MR=1
MPM7 net26 ckn net23 VNW pm1p2_svt_lp W=300n L=60n MR=1
MPM6 net14 ckn net41 VNW pm1p2_svt_lp W=150e-9 L=60e-9 MR=1
MPM5 net41 net23 VDD VNW pm1p2_svt_lp W=150e-9 L=60e-9 MR=1
MPM4 net23 net14 VDD VNW pm1p2_svt_lp W=590e-9 L=60e-9 MR=1
MPM3 net14 ckb net43 VNW pm1p2_svt_lp W=590e-9 L=60e-9 MR=1
MPM2 net43 D VDD VNW pm1p2_svt_lp W=590e-9 L=60e-9 MR=1
MPM1 ckb ckn VDD VNW pm1p2_svt_lp W=300e-9 L=60e-9 MR=1
MPM0 ckn CK VDD VNW pm1p2_svt_lp W=300e-9 L=60e-9 MR=1
.ENDS
.SUBCKT DFFQX4_9TSVT CK D Q VDD VSS VNW VPW
MNM11 Q net32 VSS VPW nm1p2_svt_lp W=1.88e-6 L=60e-9 MR=1
MNM9 net38 net32 VSS VPW nm1p2_svt_lp W=150e-9 L=60e-9 MR=1
MNM10 net26 ckn net38 VPW nm1p2_svt_lp W=150e-9 L=60e-9 MR=1
MNM8 net32 net26 VSS VPW nm1p2_svt_lp W=940e-9 L=60e-9 MR=1
MNM7 net26 ckb net23 VPW nm1p2_svt_lp W=230n L=60n MR=1
MNM5 net40 net23 VSS VPW nm1p2_svt_lp W=150e-9 L=60e-9 MR=1
MNM6 net14 ckb net40 VPW nm1p2_svt_lp W=150e-9 L=60e-9 MR=1
MNM4 net23 net14 VSS VPW nm1p2_svt_lp W=470e-9 L=60e-9 MR=1
MNM2 net42 D VSS VPW nm1p2_svt_lp W=470e-9 L=60e-9 MR=1
MNM3 net14 ckn net42 VPW nm1p2_svt_lp W=470e-9 L=60e-9 MR=1
MNM1 ckb ckn VSS VPW nm1p2_svt_lp W=230n L=60n MR=1
MNM0 ckn CK VSS VPW nm1p2_svt_lp W=230n L=60n MR=1
MPM11 Q net32 VDD VNW pm1p2_svt_lp W=2.36e-6 L=60e-9 MR=1
MPM10 net26 ckb net39 VNW pm1p2_svt_lp W=150e-9 L=60e-9 MR=1
MPM9 net39 net32 VDD VNW pm1p2_svt_lp W=150e-9 L=60e-9 MR=1
MPM8 net32 net26 VDD VNW pm1p2_svt_lp W=1.18e-6 L=60e-9 MR=1
MPM7 net26 ckn net23 VNW pm1p2_svt_lp W=300n L=60n MR=1
MPM6 net14 ckn net41 VNW pm1p2_svt_lp W=150e-9 L=60e-9 MR=1
MPM5 net41 net23 VDD VNW pm1p2_svt_lp W=150e-9 L=60e-9 MR=1
MPM4 net23 net14 VDD VNW pm1p2_svt_lp W=590e-9 L=60e-9 MR=1
MPM3 net14 ckb net43 VNW pm1p2_svt_lp W=590e-9 L=60e-9 MR=1
MPM2 net43 D VDD VNW pm1p2_svt_lp W=590e-9 L=60e-9 MR=1
MPM1 ckb ckn VDD VNW pm1p2_svt_lp W=300n L=60n MR=1
MPM0 ckn CK VDD VNW pm1p2_svt_lp W=300n L=60n MR=1
.ENDS
.SUBCKT DFFRNQX0P5_9TSVT CK D Q RN VDD VSS VNW VPW
MNM11 Q net31 VSS VPW nm1p2_svt_lp W=230e-9 L=60e-9 MR=1
MNM9 net43 net31 VSS VPW nm1p2_svt_lp W=150e-9 L=60e-9 MR=1
MNM10 net28 ckn net43 VPW nm1p2_svt_lp W=150e-9 L=60e-9 MR=1
MNM_RN2 net45 RN VSS VPW nm1p2_svt_lp W=230e-9 L=60e-9 MR=1
MNM8 net31 net28 net45 VPW nm1p2_svt_lp W=230e-9 L=60e-9 MR=1
MNM7 net28 ckb net25 VPW nm1p2_svt_lp W=230e-9 L=60e-9 MR=1
MNM_RN net46 RN VSS VPW nm1p2_svt_lp W=150e-9 L=60e-9 MR=1
MNM5 net47 net25 net46 VPW nm1p2_svt_lp W=150e-9 L=60e-9 MR=1
MNM6 net16 ckb net47 VPW nm1p2_svt_lp W=150e-9 L=60e-9 MR=1
MNM4 net25 net16 VSS VPW nm1p2_svt_lp W=230e-9 L=60e-9 MR=1
MNM2 net48 D VSS VPW nm1p2_svt_lp W=230e-9 L=60e-9 MR=1
MNM3 net16 ckn net48 VPW nm1p2_svt_lp W=230e-9 L=60e-9 MR=1
MNM1 ckb ckn VSS VPW nm1p2_svt_lp W=230e-9 L=60e-9 MR=1
MNM0 ckn CK VSS VPW nm1p2_svt_lp W=230e-9 L=60e-9 MR=1
MPM11 Q net31 VDD VNW pm1p2_svt_lp W=300e-9 L=60e-9 MR=1
MPM10 net28 ckb net44 VNW pm1p2_svt_lp W=150e-9 L=60e-9 MR=1
MPM9 net44 net31 VDD VNW pm1p2_svt_lp W=150e-9 L=60e-9 MR=1
MPM_RN2 net31 RN VDD VNW pm1p2_svt_lp W=300e-9 L=60e-9 MR=1
MPM8 net31 net28 VDD VNW pm1p2_svt_lp W=300e-9 L=60e-9 MR=1
MPM7 net28 ckn net25 VNW pm1p2_svt_lp W=300e-9 L=60e-9 MR=1
MPM6 net16 ckn net38 VNW pm1p2_svt_lp W=150e-9 L=60e-9 MR=1
MPM_RN net38 RN VDD VNW pm1p2_svt_lp W=150e-9 L=60e-9 MR=1
MPM5 net38 net25 VDD VNW pm1p2_svt_lp W=150e-9 L=60e-9 MR=1
MPM4 net25 net16 VDD VNW pm1p2_svt_lp W=300e-9 L=60e-9 MR=1
MPM3 net16 ckb net49 VNW pm1p2_svt_lp W=300e-9 L=60e-9 MR=1
MPM2 net49 D VDD VNW pm1p2_svt_lp W=300e-9 L=60e-9 MR=1
MPM1 ckb ckn VDD VNW pm1p2_svt_lp W=300e-9 L=60e-9 MR=1
MPM0 ckn CK VDD VNW pm1p2_svt_lp W=300e-9 L=60e-9 MR=1
.ENDS
.SUBCKT DFFRNQX1_9TSVT CK D Q RN VDD VSS VNW VPW
MNM11 Q net31 VSS VPW nm1p2_svt_lp W=470e-9 L=60e-9 MR=1
MNM9 net43 net31 VSS VPW nm1p2_svt_lp W=150e-9 L=60e-9 MR=1
MNM10 net28 ckn net43 VPW nm1p2_svt_lp W=150e-9 L=60e-9 MR=1
MNM_RN2 net45 RN VSS VPW nm1p2_svt_lp W=470e-9 L=60e-9 MR=1
MNM8 net31 net28 net45 VPW nm1p2_svt_lp W=470e-9 L=60e-9 MR=1
MNM7 net28 ckb net25 VPW nm1p2_svt_lp W=230n L=60n MR=1
MNM_RN net46 RN VSS VPW nm1p2_svt_lp W=150e-9 L=60e-9 MR=1
MNM5 net47 net25 net46 VPW nm1p2_svt_lp W=150e-9 L=60e-9 MR=1
MNM6 net16 ckb net47 VPW nm1p2_svt_lp W=150e-9 L=60e-9 MR=1
MNM4 net25 net16 VSS VPW nm1p2_svt_lp W=380e-9 L=60e-9 MR=1
MNM2 net48 D VSS VPW nm1p2_svt_lp W=230n L=60n MR=1
MNM3 net16 ckn net48 VPW nm1p2_svt_lp W=230n L=60n MR=1
MNM1 ckb ckn VSS VPW nm1p2_svt_lp W=230e-9 L=60e-9 MR=1
MNM0 ckn CK VSS VPW nm1p2_svt_lp W=230e-9 L=60e-9 MR=1
MPM11 Q net31 VDD VNW pm1p2_svt_lp W=590e-9 L=60e-9 MR=1
MPM10 net28 ckb net44 VNW pm1p2_svt_lp W=150e-9 L=60e-9 MR=1
MPM9 net44 net31 VDD VNW pm1p2_svt_lp W=150e-9 L=60e-9 MR=1
MPM_RN2 net31 RN VDD VNW pm1p2_svt_lp W=590e-9 L=60e-9 MR=1
MPM8 net31 net28 VDD VNW pm1p2_svt_lp W=590e-9 L=60e-9 MR=1
MPM7 net28 ckn net25 VNW pm1p2_svt_lp W=300n L=60n MR=1
MPM6 net16 ckn net38 VNW pm1p2_svt_lp W=150e-9 L=60e-9 MR=1
MPM_RN net38 RN VDD VNW pm1p2_svt_lp W=150e-9 L=60e-9 MR=1
MPM5 net38 net25 VDD VNW pm1p2_svt_lp W=150e-9 L=60e-9 MR=1
MPM4 net25 net16 VDD VNW pm1p2_svt_lp W=370e-9 L=60e-9 MR=1
MPM3 net16 ckb net49 VNW pm1p2_svt_lp W=300n L=60n MR=1
MPM2 net49 D VDD VNW pm1p2_svt_lp W=300n L=60n MR=1
MPM1 ckb ckn VDD VNW pm1p2_svt_lp W=300e-9 L=60e-9 MR=1
MPM0 ckn CK VDD VNW pm1p2_svt_lp W=300e-9 L=60e-9 MR=1
.ENDS
.SUBCKT DFFRNQX2_9TSVT CK D Q RN VDD VSS VNW VPW
MNM11 Q net31 VSS VPW nm1p2_svt_lp W=940e-9 L=60e-9 MR=1
MNM9 net43 net31 VSS VPW nm1p2_svt_lp W=150e-9 L=60e-9 MR=1
MNM10 net28 ckn net43 VPW nm1p2_svt_lp W=150e-9 L=60e-9 MR=1
MNM_RN2 net45 RN VSS VPW nm1p2_svt_lp W=470e-9 L=60e-9 MR=1
MNM8 net31 net28 net45 VPW nm1p2_svt_lp W=470e-9 L=60e-9 MR=1
MNM7 net28 ckb net25 VPW nm1p2_svt_lp W=230n L=60n MR=1
MNM_RN net46 RN VSS VPW nm1p2_svt_lp W=150e-9 L=60e-9 MR=1
MNM5 net47 net25 net46 VPW nm1p2_svt_lp W=150e-9 L=60e-9 MR=1
MNM6 net16 ckb net47 VPW nm1p2_svt_lp W=150e-9 L=60e-9 MR=1
MNM4 net25 net16 VSS VPW nm1p2_svt_lp W=380e-9 L=60e-9 MR=1
MNM2 net48 D VSS VPW nm1p2_svt_lp W=470e-9 L=60e-9 MR=1
MNM3 net16 ckn net48 VPW nm1p2_svt_lp W=470e-9 L=60e-9 MR=1
MNM1 ckb ckn VSS VPW nm1p2_svt_lp W=230e-9 L=60e-9 MR=1
MNM0 ckn CK VSS VPW nm1p2_svt_lp W=230e-9 L=60e-9 MR=1
MPM11 Q net31 VDD VNW pm1p2_svt_lp W=1.18e-6 L=60e-9 MR=1
MPM10 net28 ckb net44 VNW pm1p2_svt_lp W=150e-9 L=60e-9 MR=1
MPM9 net44 net31 VDD VNW pm1p2_svt_lp W=150e-9 L=60e-9 MR=1
MPM_RN2 net31 RN VDD VNW pm1p2_svt_lp W=590e-9 L=60e-9 MR=1
MPM8 net31 net28 VDD VNW pm1p2_svt_lp W=590e-9 L=60e-9 MR=1
MPM7 net28 ckn net25 VNW pm1p2_svt_lp W=300n L=60n MR=1
MPM6 net16 ckn net38 VNW pm1p2_svt_lp W=150e-9 L=60e-9 MR=1
MPM_RN net38 RN VDD VNW pm1p2_svt_lp W=150e-9 L=60e-9 MR=1
MPM5 net38 net25 VDD VNW pm1p2_svt_lp W=150e-9 L=60e-9 MR=1
MPM4 net25 net16 VDD VNW pm1p2_svt_lp W=370e-9 L=60e-9 MR=1
MPM3 net16 ckb net49 VNW pm1p2_svt_lp W=590e-9 L=60e-9 MR=1
MPM2 net49 D VDD VNW pm1p2_svt_lp W=590e-9 L=60e-9 MR=1
MPM1 ckb ckn VDD VNW pm1p2_svt_lp W=300e-9 L=60e-9 MR=1
MPM0 ckn CK VDD VNW pm1p2_svt_lp W=300e-9 L=60e-9 MR=1
.ENDS
.SUBCKT DFFRNQX4_9TSVT CK D Q RN VDD VSS VNW VPW
MNM11 Q net31 VSS VPW nm1p2_svt_lp W=1.88e-6 L=60e-9 MR=1
MNM9 net43 net31 VSS VPW nm1p2_svt_lp W=150e-9 L=60e-9 MR=1
MNM10 net28 ckn net43 VPW nm1p2_svt_lp W=150e-9 L=60e-9 MR=1
MNM_RN2 net45 RN VSS VPW nm1p2_svt_lp W=940e-9 L=60e-9 MR=1
MNM8 net31 net28 net45 VPW nm1p2_svt_lp W=940e-9 L=60e-9 MR=1
MNM7 net28 ckb net25 VPW nm1p2_svt_lp W=230n L=60n MR=1
MNM_RN net46 RN VSS VPW nm1p2_svt_lp W=150e-9 L=60e-9 MR=1
MNM5 net47 net25 net46 VPW nm1p2_svt_lp W=150e-9 L=60e-9 MR=1
MNM6 net16 ckb net47 VPW nm1p2_svt_lp W=150e-9 L=60e-9 MR=1
MNM4 net25 net16 VSS VPW nm1p2_svt_lp W=380e-9 L=60e-9 MR=1
MNM2 net48 D VSS VPW nm1p2_svt_lp W=470e-9 L=60e-9 MR=1
MNM3 net16 ckn net48 VPW nm1p2_svt_lp W=470e-9 L=60e-9 MR=1
MNM1 ckb ckn VSS VPW nm1p2_svt_lp W=230n L=60n MR=1
MNM0 ckn CK VSS VPW nm1p2_svt_lp W=230n L=60n MR=1
MPM11 Q net31 VDD VNW pm1p2_svt_lp W=2.36e-6 L=60e-9 MR=1
MPM10 net28 ckb net44 VNW pm1p2_svt_lp W=150e-9 L=60e-9 MR=1
MPM9 net44 net31 VDD VNW pm1p2_svt_lp W=150e-9 L=60e-9 MR=1
MPM_RN2 net31 RN VDD VNW pm1p2_svt_lp W=1.18e-6 L=60e-9 MR=1
MPM8 net31 net28 VDD VNW pm1p2_svt_lp W=1.18e-6 L=60e-9 MR=1
MPM7 net28 ckn net25 VNW pm1p2_svt_lp W=300n L=60n MR=1
MPM6 net16 ckn net38 VNW pm1p2_svt_lp W=150e-9 L=60e-9 MR=1
MPM_RN net38 RN VDD VNW pm1p2_svt_lp W=150e-9 L=60e-9 MR=1
MPM5 net38 net25 VDD VNW pm1p2_svt_lp W=150e-9 L=60e-9 MR=1
MPM4 net25 net16 VDD VNW pm1p2_svt_lp W=370e-9 L=60e-9 MR=1
MPM3 net16 ckb net49 VNW pm1p2_svt_lp W=590e-9 L=60e-9 MR=1
MPM2 net49 D VDD VNW pm1p2_svt_lp W=590e-9 L=60e-9 MR=1
MPM1 ckb ckn VDD VNW pm1p2_svt_lp W=300n L=60n MR=1
MPM0 ckn CK VDD VNW pm1p2_svt_lp W=300n L=60n MR=1
.ENDS
.SUBCKT DFFRSNQX0P5_9TSVT CK D Q RN SN VDD VSS VNW VPW
MNM11 Q net32 VSS VPW nm1p2_svt_lp W=230e-9 L=60e-9 MR=1
MNM9 net48 net32 VSS VPW nm1p2_svt_lp W=150e-9 L=60e-9 MR=1
MNM_SN2 net49 SN net48 VPW nm1p2_svt_lp W=150e-9 L=60e-9 MR=1
MNM10 net29 ckn net49 VPW nm1p2_svt_lp W=150e-9 L=60e-9 MR=1
MNM_RN2 net50 RN VSS VPW nm1p2_svt_lp W=230e-9 L=60e-9 MR=1
MNM8 net32 net29 net50 VPW nm1p2_svt_lp W=230e-9 L=60e-9 MR=1
MNM7 net29 ckb net24 VPW nm1p2_svt_lp W=230e-9 L=60e-9 MR=1
MNM_RN net51 RN VSS VPW nm1p2_svt_lp W=150e-9 L=60e-9 MR=1
MNM5 net52 net24 net51 VPW nm1p2_svt_lp W=150e-9 L=60e-9 MR=1
MNM6 net18 ckb net52 VPW nm1p2_svt_lp W=150e-9 L=60e-9 MR=1
MNM4 net53 net18 VSS VPW nm1p2_svt_lp W=230e-9 L=60e-9 MR=1
MNM_SN net24 SN net53 VPW nm1p2_svt_lp W=230e-9 L=60e-9 MR=1
MNM2 net54 D VSS VPW nm1p2_svt_lp W=230e-9 L=60e-9 MR=1
MNM3 net18 ckn net54 VPW nm1p2_svt_lp W=230e-9 L=60e-9 MR=1
MNM1 ckb ckn VSS VPW nm1p2_svt_lp W=230e-9 L=60e-9 MR=1
MNM0 ckn CK VSS VPW nm1p2_svt_lp W=230e-9 L=60e-9 MR=1
MPM11 Q net32 VDD VNW pm1p2_svt_lp W=300e-9 L=60e-9 MR=1
MPM10 net29 ckb net46 VNW pm1p2_svt_lp W=150e-9 L=60e-9 MR=1
MPM_SN2 net46 SN VDD VNW pm1p2_svt_lp W=150e-9 L=60e-9 MR=1
MPM9 net46 net32 VDD VNW pm1p2_svt_lp W=150e-9 L=60e-9 MR=1
MPM_RN2 net32 RN VDD VNW pm1p2_svt_lp W=300e-9 L=60e-9 MR=1
MPM8 net32 net29 VDD VNW pm1p2_svt_lp W=300e-9 L=60e-9 MR=1
MPM7 net29 ckn net24 VNW pm1p2_svt_lp W=300e-9 L=60e-9 MR=1
MPM6 net18 ckn net41 VNW pm1p2_svt_lp W=150e-9 L=60e-9 MR=1
MPM_RN net41 RN VDD VNW pm1p2_svt_lp W=150e-9 L=60e-9 MR=1
MPM5 net41 net24 VDD VNW pm1p2_svt_lp W=150e-9 L=60e-9 MR=1
MPM_SN net24 SN VDD VNW pm1p2_svt_lp W=300e-9 L=60e-9 MR=1
MPM4 net24 net18 VDD VNW pm1p2_svt_lp W=300e-9 L=60e-9 MR=1
MPM3 net18 ckb net55 VNW pm1p2_svt_lp W=300e-9 L=60e-9 MR=1
MPM2 net55 D VDD VNW pm1p2_svt_lp W=300e-9 L=60e-9 MR=1
MPM1 ckb ckn VDD VNW pm1p2_svt_lp W=300e-9 L=60e-9 MR=1
MPM0 ckn CK VDD VNW pm1p2_svt_lp W=300e-9 L=60e-9 MR=1
.ENDS
.SUBCKT DFFRSNQX1_9TSVT CK D Q RN SN VDD VSS VNW VPW
MNM11 Q net32 VSS VPW nm1p2_svt_lp W=470e-9 L=60e-9 MR=1
MNM9 net48 net32 VSS VPW nm1p2_svt_lp W=150e-9 L=60e-9 MR=1
MNM_SN2 net49 SN net48 VPW nm1p2_svt_lp W=150e-9 L=60e-9 MR=1
MNM10 net29 ckn net49 VPW nm1p2_svt_lp W=150e-9 L=60e-9 MR=1
MNM_RN2 net50 RN VSS VPW nm1p2_svt_lp W=470e-9 L=60e-9 MR=1
MNM8 net32 net29 net50 VPW nm1p2_svt_lp W=470e-9 L=60e-9 MR=1
MNM7 net29 ckb net24 VPW nm1p2_svt_lp W=230n L=60n MR=1
MNM_RN net51 RN VSS VPW nm1p2_svt_lp W=150e-9 L=60e-9 MR=1
MNM5 net52 net24 net51 VPW nm1p2_svt_lp W=150e-9 L=60e-9 MR=1
MNM6 net18 ckb net52 VPW nm1p2_svt_lp W=150e-9 L=60e-9 MR=1
MNM4 net53 net18 VSS VPW nm1p2_svt_lp W=470e-9 L=60e-9 MR=1
MNM_SN net24 SN net53 VPW nm1p2_svt_lp W=470e-9 L=60e-9 MR=1
MNM2 net54 D VSS VPW nm1p2_svt_lp W=230n L=60n MR=1
MNM3 net18 ckn net54 VPW nm1p2_svt_lp W=230n L=60n MR=1
MNM1 ckb ckn VSS VPW nm1p2_svt_lp W=230e-9 L=60e-9 MR=1
MNM0 ckn CK VSS VPW nm1p2_svt_lp W=230e-9 L=60e-9 MR=1
MPM11 Q net32 VDD VNW pm1p2_svt_lp W=590e-9 L=60e-9 MR=1
MPM10 net29 ckb net46 VNW pm1p2_svt_lp W=150e-9 L=60e-9 MR=1
MPM_SN2 net46 SN VDD VNW pm1p2_svt_lp W=150e-9 L=60e-9 MR=1
MPM9 net46 net32 VDD VNW pm1p2_svt_lp W=150e-9 L=60e-9 MR=1
MPM_RN2 net32 RN VDD VNW pm1p2_svt_lp W=590e-9 L=60e-9 MR=1
MPM8 net32 net29 VDD VNW pm1p2_svt_lp W=590e-9 L=60e-9 MR=1
MPM7 net29 ckn net24 VNW pm1p2_svt_lp W=300n L=60n MR=1
MPM6 net18 ckn net41 VNW pm1p2_svt_lp W=150e-9 L=60e-9 MR=1
MPM_RN net41 RN VDD VNW pm1p2_svt_lp W=150e-9 L=60e-9 MR=1
MPM5 net41 net24 VDD VNW pm1p2_svt_lp W=150e-9 L=60e-9 MR=1
MPM_SN net24 SN VDD VNW pm1p2_svt_lp W=370e-9 L=60e-9 MR=1
MPM4 net24 net18 VDD VNW pm1p2_svt_lp W=390e-9 L=60e-9 MR=1
MPM3 net18 ckb net55 VNW pm1p2_svt_lp W=300n L=60n MR=1
MPM2 net55 D VDD VNW pm1p2_svt_lp W=300n L=60n MR=1
MPM1 ckb ckn VDD VNW pm1p2_svt_lp W=300e-9 L=60e-9 MR=1
MPM0 ckn CK VDD VNW pm1p2_svt_lp W=300e-9 L=60e-9 MR=1
.ENDS
.SUBCKT DFFRSNQX2_9TSVT CK D Q RN SN VDD VSS VNW VPW
MNM11 Q net32 VSS VPW nm1p2_svt_lp W=940e-9 L=60e-9 MR=1
MNM9 net48 net32 VSS VPW nm1p2_svt_lp W=150e-9 L=60e-9 MR=1
MNM_SN2 net49 SN net48 VPW nm1p2_svt_lp W=150e-9 L=60e-9 MR=1
MNM10 net29 ckn net49 VPW nm1p2_svt_lp W=150e-9 L=60e-9 MR=1
MNM_RN2 net50 RN VSS VPW nm1p2_svt_lp W=470e-9 L=60e-9 MR=1
MNM8 net32 net29 net50 VPW nm1p2_svt_lp W=470e-9 L=60e-9 MR=1
MNM7 net29 ckb net24 VPW nm1p2_svt_lp W=230n L=60n MR=1
MNM_RN net51 RN VSS VPW nm1p2_svt_lp W=150e-9 L=60e-9 MR=1
MNM5 net52 net24 net51 VPW nm1p2_svt_lp W=150e-9 L=60e-9 MR=1
MNM6 net18 ckb net52 VPW nm1p2_svt_lp W=150e-9 L=60e-9 MR=1
MNM4 net53 net18 VSS VPW nm1p2_svt_lp W=470e-9 L=60e-9 MR=1
MNM_SN net24 SN net53 VPW nm1p2_svt_lp W=470e-9 L=60e-9 MR=1
MNM2 net54 D VSS VPW nm1p2_svt_lp W=470e-9 L=60e-9 MR=1
MNM3 net18 ckn net54 VPW nm1p2_svt_lp W=470e-9 L=60e-9 MR=1
MNM1 ckb ckn VSS VPW nm1p2_svt_lp W=230e-9 L=60e-9 MR=1
MNM0 ckn CK VSS VPW nm1p2_svt_lp W=230e-9 L=60e-9 MR=1
MPM11 Q net32 VDD VNW pm1p2_svt_lp W=1.18e-6 L=60e-9 MR=1
MPM10 net29 ckb net46 VNW pm1p2_svt_lp W=150e-9 L=60e-9 MR=1
MPM_SN2 net46 SN VDD VNW pm1p2_svt_lp W=150e-9 L=60e-9 MR=1
MPM9 net46 net32 VDD VNW pm1p2_svt_lp W=150e-9 L=60e-9 MR=1
MPM_RN2 net32 RN VDD VNW pm1p2_svt_lp W=590e-9 L=60e-9 MR=1
MPM8 net32 net29 VDD VNW pm1p2_svt_lp W=590e-9 L=60e-9 MR=1
MPM7 net29 ckn net24 VNW pm1p2_svt_lp W=300n L=60n MR=1
MPM6 net18 ckn net41 VNW pm1p2_svt_lp W=150e-9 L=60e-9 MR=1
MPM_RN net41 RN VDD VNW pm1p2_svt_lp W=150e-9 L=60e-9 MR=1
MPM5 net41 net24 VDD VNW pm1p2_svt_lp W=150e-9 L=60e-9 MR=1
MPM_SN net24 SN VDD VNW pm1p2_svt_lp W=370e-9 L=60e-9 MR=1
MPM4 net24 net18 VDD VNW pm1p2_svt_lp W=390e-9 L=60e-9 MR=1
MPM3 net18 ckb net55 VNW pm1p2_svt_lp W=590e-9 L=60e-9 MR=1
MPM2 net55 D VDD VNW pm1p2_svt_lp W=590e-9 L=60e-9 MR=1
MPM1 ckb ckn VDD VNW pm1p2_svt_lp W=300e-9 L=60e-9 MR=1
MPM0 ckn CK VDD VNW pm1p2_svt_lp W=300e-9 L=60e-9 MR=1
.ENDS
.SUBCKT DFFRSNQX4_9TSVT CK D Q RN SN VDD VSS VNW VPW
MNM11 Q net32 VSS VPW nm1p2_svt_lp W=1.88e-6 L=60e-9 MR=1
MNM9 net48 net32 VSS VPW nm1p2_svt_lp W=150e-9 L=60e-9 MR=1
MNM_SN2 net49 SN net48 VPW nm1p2_svt_lp W=150e-9 L=60e-9 MR=1
MNM10 net29 ckn net49 VPW nm1p2_svt_lp W=150e-9 L=60e-9 MR=1
MNM_RN2 net50 RN VSS VPW nm1p2_svt_lp W=940e-9 L=60e-9 MR=1
MNM8 net32 net29 net50 VPW nm1p2_svt_lp W=940e-9 L=60e-9 MR=1
MNM7 net29 ckb net24 VPW nm1p2_svt_lp W=230n L=60n MR=1
MNM_RN net51 RN VSS VPW nm1p2_svt_lp W=150e-9 L=60e-9 MR=1
MNM5 net52 net24 net51 VPW nm1p2_svt_lp W=150e-9 L=60e-9 MR=1
MNM6 net18 ckb net52 VPW nm1p2_svt_lp W=150e-9 L=60e-9 MR=1
MNM4 net53 net18 VSS VPW nm1p2_svt_lp W=470e-9 L=60e-9 MR=1
MNM_SN net24 SN net53 VPW nm1p2_svt_lp W=470e-9 L=60e-9 MR=1
MNM2 net54 D VSS VPW nm1p2_svt_lp W=470e-9 L=60e-9 MR=1
MNM3 net18 ckn net54 VPW nm1p2_svt_lp W=470e-9 L=60e-9 MR=1
MNM1 ckb ckn VSS VPW nm1p2_svt_lp W=230n L=60n MR=1
MNM0 ckn CK VSS VPW nm1p2_svt_lp W=230n L=60n MR=1
MPM11 Q net32 VDD VNW pm1p2_svt_lp W=2.36e-6 L=60e-9 MR=1
MPM10 net29 ckb net46 VNW pm1p2_svt_lp W=150e-9 L=60e-9 MR=1
MPM_SN2 net46 SN VDD VNW pm1p2_svt_lp W=150e-9 L=60e-9 MR=1
MPM9 net46 net32 VDD VNW pm1p2_svt_lp W=150e-9 L=60e-9 MR=1
MPM_RN2 net32 RN VDD VNW pm1p2_svt_lp W=1.18e-6 L=60e-9 MR=1
MPM8 net32 net29 VDD VNW pm1p2_svt_lp W=1.18e-6 L=60e-9 MR=1
MPM7 net29 ckn net24 VNW pm1p2_svt_lp W=300n L=60n MR=1
MPM6 net18 ckn net41 VNW pm1p2_svt_lp W=150e-9 L=60e-9 MR=1
MPM_RN net41 RN VDD VNW pm1p2_svt_lp W=150e-9 L=60e-9 MR=1
MPM5 net41 net24 VDD VNW pm1p2_svt_lp W=150e-9 L=60e-9 MR=1
MPM_SN net24 SN VDD VNW pm1p2_svt_lp W=370e-9 L=60e-9 MR=1
MPM4 net24 net18 VDD VNW pm1p2_svt_lp W=390e-9 L=60e-9 MR=1
MPM3 net18 ckb net55 VNW pm1p2_svt_lp W=590e-9 L=60e-9 MR=1
MPM2 net55 D VDD VNW pm1p2_svt_lp W=590e-9 L=60e-9 MR=1
MPM1 ckb ckn VDD VNW pm1p2_svt_lp W=300n L=60n MR=1
MPM0 ckn CK VDD VNW pm1p2_svt_lp W=300n L=60n MR=1
.ENDS
.SUBCKT DFFSNQX0P5_9TSVT CK D Q SN VDD VSS VNW VPW
MNM11 Q net33 VSS VPW nm1p2_svt_lp W=230e-9 L=60e-9 MR=1
MNM9 net43 net33 VSS VPW nm1p2_svt_lp W=150e-9 L=60e-9 MR=1
MNM_SN2 net44 SN net43 VPW nm1p2_svt_lp W=150e-9 L=60e-9 MR=1
MNM10 net27 ckn net44 VPW nm1p2_svt_lp W=150e-9 L=60e-9 MR=1
MNM8 net33 net27 VSS VPW nm1p2_svt_lp W=230e-9 L=60e-9 MR=1
MNM7 net27 ckb net22 VPW nm1p2_svt_lp W=230e-9 L=60e-9 MR=1
MNM5 net45 net22 VSS VPW nm1p2_svt_lp W=150e-9 L=60e-9 MR=1
MNM6 net16 ckb net45 VPW nm1p2_svt_lp W=150e-9 L=60e-9 MR=1
MNM4 net47 net16 VSS VPW nm1p2_svt_lp W=230e-9 L=60e-9 MR=1
MNM_SN net22 SN net47 VPW nm1p2_svt_lp W=230e-9 L=60e-9 MR=1
MNM2 net48 D VSS VPW nm1p2_svt_lp W=230e-9 L=60e-9 MR=1
MNM3 net16 ckn net48 VPW nm1p2_svt_lp W=230e-9 L=60e-9 MR=1
MNM1 ckb ckn VSS VPW nm1p2_svt_lp W=230e-9 L=60e-9 MR=1
MNM0 ckn CK VSS VPW nm1p2_svt_lp W=230e-9 L=60e-9 MR=1
MPM11 Q net33 VDD VNW pm1p2_svt_lp W=300e-9 L=60e-9 MR=1
MPM10 net27 ckb net41 VNW pm1p2_svt_lp W=150e-9 L=60e-9 MR=1
MPM_SN2 net41 SN VDD VNW pm1p2_svt_lp W=150e-9 L=60e-9 MR=1
MPM9 net41 net33 VDD VNW pm1p2_svt_lp W=150e-9 L=60e-9 MR=1
MPM8 net33 net27 VDD VNW pm1p2_svt_lp W=300e-9 L=60e-9 MR=1
MPM7 net27 ckn net22 VNW pm1p2_svt_lp W=300e-9 L=60e-9 MR=1
MPM6 net16 ckn net46 VNW pm1p2_svt_lp W=150e-9 L=60e-9 MR=1
MPM5 net46 net22 VDD VNW pm1p2_svt_lp W=150e-9 L=60e-9 MR=1
MPM_SN net22 SN VDD VNW pm1p2_svt_lp W=300e-9 L=60e-9 MR=1
MPM4 net22 net16 VDD VNW pm1p2_svt_lp W=300e-9 L=60e-9 MR=1
MPM3 net16 ckb net49 VNW pm1p2_svt_lp W=300e-9 L=60e-9 MR=1
MPM2 net49 D VDD VNW pm1p2_svt_lp W=300e-9 L=60e-9 MR=1
MPM1 ckb ckn VDD VNW pm1p2_svt_lp W=300e-9 L=60e-9 MR=1
MPM0 ckn CK VDD VNW pm1p2_svt_lp W=300e-9 L=60e-9 MR=1
.ENDS
.SUBCKT DFFSNQX1_9TSVT CK D Q SN VDD VSS VNW VPW
MNM11 Q net33 VSS VPW nm1p2_svt_lp W=470e-9 L=60e-9 MR=1
MNM9 net43 net33 VSS VPW nm1p2_svt_lp W=150e-9 L=60e-9 MR=1
MNM_SN2 net44 SN net43 VPW nm1p2_svt_lp W=150e-9 L=60e-9 MR=1
MNM10 net27 ckn net44 VPW nm1p2_svt_lp W=150e-9 L=60e-9 MR=1
MNM8 net33 net27 VSS VPW nm1p2_svt_lp W=470e-9 L=60e-9 MR=1
MNM7 net27 ckb net22 VPW nm1p2_svt_lp W=230n L=60n MR=1
MNM5 net45 net22 VSS VPW nm1p2_svt_lp W=150e-9 L=60e-9 MR=1
MNM6 net16 ckb net45 VPW nm1p2_svt_lp W=150e-9 L=60e-9 MR=1
MNM4 net47 net16 VSS VPW nm1p2_svt_lp W=470e-9 L=60e-9 MR=1
MNM_SN net22 SN net47 VPW nm1p2_svt_lp W=470e-9 L=60e-9 MR=1
MNM2 net48 D VSS VPW nm1p2_svt_lp W=230n L=60n MR=1
MNM3 net16 ckn net48 VPW nm1p2_svt_lp W=230n L=60n MR=1
MNM1 ckb ckn VSS VPW nm1p2_svt_lp W=230e-9 L=60e-9 MR=1
MNM0 ckn CK VSS VPW nm1p2_svt_lp W=230e-9 L=60e-9 MR=1
MPM11 Q net33 VDD VNW pm1p2_svt_lp W=590e-9 L=60e-9 MR=1
MPM10 net27 ckb net41 VNW pm1p2_svt_lp W=150e-9 L=60e-9 MR=1
MPM_SN2 net41 SN VDD VNW pm1p2_svt_lp W=150e-9 L=60e-9 MR=1
MPM9 net41 net33 VDD VNW pm1p2_svt_lp W=150e-9 L=60e-9 MR=1
MPM8 net33 net27 VDD VNW pm1p2_svt_lp W=590e-9 L=60e-9 MR=1
MPM7 net27 ckn net22 VNW pm1p2_svt_lp W=300n L=60n MR=1
MPM6 net16 ckn net46 VNW pm1p2_svt_lp W=150e-9 L=60e-9 MR=1
MPM5 net46 net22 VDD VNW pm1p2_svt_lp W=150e-9 L=60e-9 MR=1
MPM_SN net22 SN VDD VNW pm1p2_svt_lp W=590e-9 L=60e-9 MR=1
MPM4 net22 net16 VDD VNW pm1p2_svt_lp W=590e-9 L=60e-9 MR=1
MPM3 net16 ckb net49 VNW pm1p2_svt_lp W=300n L=60n MR=1
MPM2 net49 D VDD VNW pm1p2_svt_lp W=300n L=60n MR=1
MPM1 ckb ckn VDD VNW pm1p2_svt_lp W=300e-9 L=60e-9 MR=1
MPM0 ckn CK VDD VNW pm1p2_svt_lp W=300e-9 L=60e-9 MR=1
.ENDS
.SUBCKT DFFSNQX2_9TSVT CK D Q SN VDD VSS VNW VPW
MNM11 Q net33 VSS VPW nm1p2_svt_lp W=940e-9 L=60e-9 MR=1
MNM9 net43 net33 VSS VPW nm1p2_svt_lp W=150e-9 L=60e-9 MR=1
MNM_SN2 net44 SN net43 VPW nm1p2_svt_lp W=150e-9 L=60e-9 MR=1
MNM10 net27 ckn net44 VPW nm1p2_svt_lp W=150e-9 L=60e-9 MR=1
MNM8 net33 net27 VSS VPW nm1p2_svt_lp W=470e-9 L=60e-9 MR=1
MNM7 net27 ckb net22 VPW nm1p2_svt_lp W=230n L=60n MR=1
MNM5 net45 net22 VSS VPW nm1p2_svt_lp W=150e-9 L=60e-9 MR=1
MNM6 net16 ckb net45 VPW nm1p2_svt_lp W=150e-9 L=60e-9 MR=1
MNM4 net47 net16 VSS VPW nm1p2_svt_lp W=470e-9 L=60e-9 MR=1
MNM_SN net22 SN net47 VPW nm1p2_svt_lp W=470e-9 L=60e-9 MR=1
MNM2 net48 D VSS VPW nm1p2_svt_lp W=230n L=60n MR=1
MNM3 net16 ckn net48 VPW nm1p2_svt_lp W=230n L=60n MR=1
MNM1 ckb ckn VSS VPW nm1p2_svt_lp W=230e-9 L=60e-9 MR=1
MNM0 ckn CK VSS VPW nm1p2_svt_lp W=230e-9 L=60e-9 MR=1
MPM11 Q net33 VDD VNW pm1p2_svt_lp W=1.18e-6 L=60e-9 MR=1
MPM10 net27 ckb net41 VNW pm1p2_svt_lp W=150e-9 L=60e-9 MR=1
MPM_SN2 net41 SN VDD VNW pm1p2_svt_lp W=150e-9 L=60e-9 MR=1
MPM9 net41 net33 VDD VNW pm1p2_svt_lp W=150e-9 L=60e-9 MR=1
MPM8 net33 net27 VDD VNW pm1p2_svt_lp W=590e-9 L=60e-9 MR=1
MPM7 net27 ckn net22 VNW pm1p2_svt_lp W=300n L=60n MR=1
MPM6 net16 ckn net46 VNW pm1p2_svt_lp W=150e-9 L=60e-9 MR=1
MPM5 net46 net22 VDD VNW pm1p2_svt_lp W=150e-9 L=60e-9 MR=1
MPM_SN net22 SN VDD VNW pm1p2_svt_lp W=590e-9 L=60e-9 MR=1
MPM4 net22 net16 VDD VNW pm1p2_svt_lp W=590e-9 L=60e-9 MR=1
MPM3 net16 ckb net49 VNW pm1p2_svt_lp W=300n L=60n MR=1
MPM2 net49 D VDD VNW pm1p2_svt_lp W=300n L=60n MR=1
MPM1 ckb ckn VDD VNW pm1p2_svt_lp W=300e-9 L=60e-9 MR=1
MPM0 ckn CK VDD VNW pm1p2_svt_lp W=300e-9 L=60e-9 MR=1
.ENDS
.SUBCKT DFFSNQX4_9TSVT CK D Q SN VDD VSS VNW VPW
MNM11 Q net33 VSS VPW nm1p2_svt_lp W=1.88e-6 L=60e-9 MR=1
MNM9 net43 net33 VSS VPW nm1p2_svt_lp W=150e-9 L=60e-9 MR=1
MNM_SN2 net44 SN net43 VPW nm1p2_svt_lp W=150e-9 L=60e-9 MR=1
MNM10 net27 ckn net44 VPW nm1p2_svt_lp W=150e-9 L=60e-9 MR=1
MNM8 net33 net27 VSS VPW nm1p2_svt_lp W=940e-9 L=60e-9 MR=1
MNM7 net27 ckb net22 VPW nm1p2_svt_lp W=230n L=60n MR=1
MNM5 net45 net22 VSS VPW nm1p2_svt_lp W=150e-9 L=60e-9 MR=1
MNM6 net16 ckb net45 VPW nm1p2_svt_lp W=150e-9 L=60e-9 MR=1
MNM4 net47 net16 VSS VPW nm1p2_svt_lp W=470e-9 L=60e-9 MR=1
MNM_SN net22 SN net47 VPW nm1p2_svt_lp W=470e-9 L=60e-9 MR=1
MNM2 net48 D VSS VPW nm1p2_svt_lp W=470e-9 L=60e-9 MR=1
MNM3 net16 ckn net48 VPW nm1p2_svt_lp W=470e-9 L=60e-9 MR=1
MNM1 ckb ckn VSS VPW nm1p2_svt_lp W=230n L=60n MR=1
MNM0 ckn CK VSS VPW nm1p2_svt_lp W=230n L=60n MR=1
MPM11 Q net33 VDD VNW pm1p2_svt_lp W=2.36e-6 L=60e-9 MR=1
MPM10 net27 ckb net41 VNW pm1p2_svt_lp W=150e-9 L=60e-9 MR=1
MPM_SN2 net41 SN VDD VNW pm1p2_svt_lp W=150e-9 L=60e-9 MR=1
MPM9 net41 net33 VDD VNW pm1p2_svt_lp W=150e-9 L=60e-9 MR=1
MPM8 net33 net27 VDD VNW pm1p2_svt_lp W=1.18e-6 L=60e-9 MR=1
MPM7 net27 ckn net22 VNW pm1p2_svt_lp W=300n L=60n MR=1
MPM6 net16 ckn net46 VNW pm1p2_svt_lp W=150e-9 L=60e-9 MR=1
MPM5 net46 net22 VDD VNW pm1p2_svt_lp W=150e-9 L=60e-9 MR=1
MPM_SN net22 SN VDD VNW pm1p2_svt_lp W=590e-9 L=60e-9 MR=1
MPM4 net22 net16 VDD VNW pm1p2_svt_lp W=590e-9 L=60e-9 MR=1
MPM3 net16 ckb net49 VNW pm1p2_svt_lp W=590e-9 L=60e-9 MR=1
MPM2 net49 D VDD VNW pm1p2_svt_lp W=590e-9 L=60e-9 MR=1
MPM1 ckb ckn VDD VNW pm1p2_svt_lp W=300n L=60n MR=1
MPM0 ckn CK VDD VNW pm1p2_svt_lp W=300n L=60n MR=1
.ENDS
.SUBCKT DFFXQX0P5_9TSVT CK D0 D1 Q S VDD VSS VNW VPW
MNM11 Q net40 VSS VPW nm1p2_svt_lp W=230e-9 L=60e-9 MR=1
MNM9 net46 net40 VSS VPW nm1p2_svt_lp W=150e-9 L=60e-9 MR=1
MNM10 net34 ckn net46 VPW nm1p2_svt_lp W=150e-9 L=60e-9 MR=1
MNM8 net40 net34 VSS VPW nm1p2_svt_lp W=230e-9 L=60e-9 MR=1
MNM7 net34 ckb net31 VPW nm1p2_svt_lp W=230e-9 L=60e-9 MR=1
MNM5 net48 net31 VSS VPW nm1p2_svt_lp W=150e-9 L=60e-9 MR=1
MNM6 net22 ckb net48 VPW nm1p2_svt_lp W=150e-9 L=60e-9 MR=1
MNM4 net31 net22 VSS VPW nm1p2_svt_lp W=230e-9 L=60e-9 MR=1
MNM_SE0 sen S VSS VPW nm1p2_svt_lp W=230e-9 L=60e-9 MR=1
MNMR2 net50 D1 VSS VPW nm1p2_svt_lp W=230e-9 L=60e-9 MR=1
MNML2 net51 D0 VSS VPW nm1p2_svt_lp W=230e-9 L=60e-9 MR=1
MNM_SE2 net18 sen net50 VPW nm1p2_svt_lp W=230e-9 L=60e-9 MR=1
MNM_SE1 net18 S net51 VPW nm1p2_svt_lp W=230e-9 L=60e-9 MR=1
MNM3 net22 ckn net18 VPW nm1p2_svt_lp W=230e-9 L=60e-9 MR=1
MNM1 ckb ckn VSS VPW nm1p2_svt_lp W=230e-9 L=60e-9 MR=1
MNM0 ckn CK VSS VPW nm1p2_svt_lp W=230e-9 L=60e-9 MR=1
MPM11 Q net40 VDD VNW pm1p2_svt_lp W=300e-9 L=60e-9 MR=1
MPM10 net34 ckb net47 VNW pm1p2_svt_lp W=150e-9 L=60e-9 MR=1
MPM9 net47 net40 VDD VNW pm1p2_svt_lp W=150e-9 L=60e-9 MR=1
MPM8 net40 net34 VDD VNW pm1p2_svt_lp W=300e-9 L=60e-9 MR=1
MPM7 net34 ckn net31 VNW pm1p2_svt_lp W=300e-9 L=60e-9 MR=1
MPM6 net22 ckn net49 VNW pm1p2_svt_lp W=150e-9 L=60e-9 MR=1
MPM5 net49 net31 VDD VNW pm1p2_svt_lp W=150e-9 L=60e-9 MR=1
MPM4 net31 net22 VDD VNW pm1p2_svt_lp W=300e-9 L=60e-9 MR=1
MPM_SE0 sen S VDD VNW pm1p2_svt_lp W=300e-9 L=60e-9 MR=1
MPM3 net22 ckb net18 VNW pm1p2_svt_lp W=300e-9 L=60e-9 MR=1
MPMR2 net52 D1 VDD VNW pm1p2_svt_lp W=300e-9 L=60e-9 MR=1
MPML2 net53 D0 VDD VNW pm1p2_svt_lp W=300e-9 L=60e-9 MR=1
MPM_SE2 net18 S net52 VNW pm1p2_svt_lp W=300e-9 L=60e-9 MR=1
MPM_SE1 net18 sen net53 VNW pm1p2_svt_lp W=300e-9 L=60e-9 MR=1
MPM1 ckb ckn VDD VNW pm1p2_svt_lp W=300e-9 L=60e-9 MR=1
MPM0 ckn CK VDD VNW pm1p2_svt_lp W=300e-9 L=60e-9 MR=1
.ENDS
.SUBCKT DFFXQX1_9TSVT CK D0 D1 Q S VDD VSS VNW VPW
MNM11 Q net40 VSS VPW nm1p2_svt_lp W=470e-9 L=60e-9 MR=1
MNM9 net46 net40 VSS VPW nm1p2_svt_lp W=150e-9 L=60e-9 MR=1
MNM10 net34 ckn net46 VPW nm1p2_svt_lp W=150e-9 L=60e-9 MR=1
MNM8 net40 net34 VSS VPW nm1p2_svt_lp W=470e-9 L=60e-9 MR=1
MNM7 net34 ckb net31 VPW nm1p2_svt_lp W=470e-9 L=60e-9 MR=1
MNM5 net48 net31 VSS VPW nm1p2_svt_lp W=150e-9 L=60e-9 MR=1
MNM6 net22 ckb net48 VPW nm1p2_svt_lp W=150e-9 L=60e-9 MR=1
MNM4 net31 net22 VSS VPW nm1p2_svt_lp W=470e-9 L=60e-9 MR=1
MNM_SE0 sen S VSS VPW nm1p2_svt_lp W=230e-9 L=60e-9 MR=1
MNMR2 net50 D1 VSS VPW nm1p2_svt_lp W=470e-9 L=60e-9 MR=1
MNML2 net51 D0 VSS VPW nm1p2_svt_lp W=470e-9 L=60e-9 MR=1
MNM_SE2 net18 sen net50 VPW nm1p2_svt_lp W=470e-9 L=60e-9 MR=1
MNM_SE1 net18 S net51 VPW nm1p2_svt_lp W=470e-9 L=60e-9 MR=1
MNM3 net22 ckn net18 VPW nm1p2_svt_lp W=470e-9 L=60e-9 MR=1
MNM1 ckb ckn VSS VPW nm1p2_svt_lp W=230e-9 L=60e-9 MR=1
MNM0 ckn CK VSS VPW nm1p2_svt_lp W=230e-9 L=60e-9 MR=1
MPM11 Q net40 VDD VNW pm1p2_svt_lp W=590e-9 L=60e-9 MR=1
MPM10 net34 ckb net47 VNW pm1p2_svt_lp W=150e-9 L=60e-9 MR=1
MPM9 net47 net40 VDD VNW pm1p2_svt_lp W=150e-9 L=60e-9 MR=1
MPM8 net40 net34 VDD VNW pm1p2_svt_lp W=590e-9 L=60e-9 MR=1
MPM7 net34 ckn net31 VNW pm1p2_svt_lp W=590e-9 L=60e-9 MR=1
MPM6 net22 ckn net49 VNW pm1p2_svt_lp W=150e-9 L=60e-9 MR=1
MPM5 net49 net31 VDD VNW pm1p2_svt_lp W=150e-9 L=60e-9 MR=1
MPM4 net31 net22 VDD VNW pm1p2_svt_lp W=590e-9 L=60e-9 MR=1
MPM_SE0 sen S VDD VNW pm1p2_svt_lp W=300e-9 L=60e-9 MR=1
MPM3 net22 ckb net18 VNW pm1p2_svt_lp W=590e-9 L=60e-9 MR=1
MPMR2 net52 D1 VDD VNW pm1p2_svt_lp W=590e-9 L=60e-9 MR=1
MPML2 net53 D0 VDD VNW pm1p2_svt_lp W=590e-9 L=60e-9 MR=1
MPM_SE2 net18 S net52 VNW pm1p2_svt_lp W=590e-9 L=60e-9 MR=1
MPM_SE1 net18 sen net53 VNW pm1p2_svt_lp W=590e-9 L=60e-9 MR=1
MPM1 ckb ckn VDD VNW pm1p2_svt_lp W=300e-9 L=60e-9 MR=1
MPM0 ckn CK VDD VNW pm1p2_svt_lp W=300e-9 L=60e-9 MR=1
.ENDS
.SUBCKT DFFXQX2_9TSVT CK D0 D1 Q S VDD VSS VNW VPW
MNM11 Q net40 VSS VPW nm1p2_svt_lp W=940e-9 L=60e-9 MR=1
MNM9 net46 net40 VSS VPW nm1p2_svt_lp W=150e-9 L=60e-9 MR=1
MNM10 net34 ckn net46 VPW nm1p2_svt_lp W=150e-9 L=60e-9 MR=1
MNM8 net40 net34 VSS VPW nm1p2_svt_lp W=470e-9 L=60e-9 MR=1
MNM7 net34 ckb net31 VPW nm1p2_svt_lp W=470e-9 L=60e-9 MR=1
MNM5 net48 net31 VSS VPW nm1p2_svt_lp W=150e-9 L=60e-9 MR=1
MNM6 net22 ckb net48 VPW nm1p2_svt_lp W=150e-9 L=60e-9 MR=1
MNM4 net31 net22 VSS VPW nm1p2_svt_lp W=470e-9 L=60e-9 MR=1
MNM_SE0 sen S VSS VPW nm1p2_svt_lp W=230e-9 L=60e-9 MR=1
MNMR2 net50 D1 VSS VPW nm1p2_svt_lp W=470e-9 L=60e-9 MR=1
MNML2 net51 D0 VSS VPW nm1p2_svt_lp W=470e-9 L=60e-9 MR=1
MNM_SE2 net18 sen net50 VPW nm1p2_svt_lp W=470e-9 L=60e-9 MR=1
MNM_SE1 net18 S net51 VPW nm1p2_svt_lp W=470e-9 L=60e-9 MR=1
MNM3 net22 ckn net18 VPW nm1p2_svt_lp W=470e-9 L=60e-9 MR=1
MNM1 ckb ckn VSS VPW nm1p2_svt_lp W=230e-9 L=60e-9 MR=1
MNM0 ckn CK VSS VPW nm1p2_svt_lp W=230e-9 L=60e-9 MR=1
MPM11 Q net40 VDD VNW pm1p2_svt_lp W=1.18e-6 L=60e-9 MR=1
MPM10 net34 ckb net47 VNW pm1p2_svt_lp W=150e-9 L=60e-9 MR=1
MPM9 net47 net40 VDD VNW pm1p2_svt_lp W=150e-9 L=60e-9 MR=1
MPM8 net40 net34 VDD VNW pm1p2_svt_lp W=590e-9 L=60e-9 MR=1
MPM7 net34 ckn net31 VNW pm1p2_svt_lp W=590e-9 L=60e-9 MR=1
MPM6 net22 ckn net49 VNW pm1p2_svt_lp W=150e-9 L=60e-9 MR=1
MPM5 net49 net31 VDD VNW pm1p2_svt_lp W=150e-9 L=60e-9 MR=1
MPM4 net31 net22 VDD VNW pm1p2_svt_lp W=590e-9 L=60e-9 MR=1
MPM_SE0 sen S VDD VNW pm1p2_svt_lp W=300e-9 L=60e-9 MR=1
MPM3 net22 ckb net18 VNW pm1p2_svt_lp W=590e-9 L=60e-9 MR=1
MPMR2 net52 D1 VDD VNW pm1p2_svt_lp W=590e-9 L=60e-9 MR=1
MPML2 net53 D0 VDD VNW pm1p2_svt_lp W=590e-9 L=60e-9 MR=1
MPM_SE2 net18 S net52 VNW pm1p2_svt_lp W=590e-9 L=60e-9 MR=1
MPM_SE1 net18 sen net53 VNW pm1p2_svt_lp W=590e-9 L=60e-9 MR=1
MPM1 ckb ckn VDD VNW pm1p2_svt_lp W=300e-9 L=60e-9 MR=1
MPM0 ckn CK VDD VNW pm1p2_svt_lp W=300e-9 L=60e-9 MR=1
.ENDS
.SUBCKT DFFXQX4_9TSVT CK D0 D1 Q S VDD VSS VNW VPW
MNM11 Q net40 VSS VPW nm1p2_svt_lp W=1.88e-6 L=60e-9 MR=1
MNM9 net46 net40 VSS VPW nm1p2_svt_lp W=150e-9 L=60e-9 MR=1
MNM10 net34 ckn net46 VPW nm1p2_svt_lp W=150e-9 L=60e-9 MR=1
MNM8 net40 net34 VSS VPW nm1p2_svt_lp W=940e-9 L=60e-9 MR=1
MNM7 net34 ckb net31 VPW nm1p2_svt_lp W=470e-9 L=60e-9 MR=1
MNM5 net48 net31 VSS VPW nm1p2_svt_lp W=150e-9 L=60e-9 MR=1
MNM6 net22 ckb net48 VPW nm1p2_svt_lp W=150e-9 L=60e-9 MR=1
MNM4 net31 net22 VSS VPW nm1p2_svt_lp W=470e-9 L=60e-9 MR=1
MNM_SE0 sen S VSS VPW nm1p2_svt_lp W=230e-9 L=60e-9 MR=1
MNMR2 net50 D1 VSS VPW nm1p2_svt_lp W=470e-9 L=60e-9 MR=1
MNML2 net51 D0 VSS VPW nm1p2_svt_lp W=470e-9 L=60e-9 MR=1
MNM_SE2 net18 sen net50 VPW nm1p2_svt_lp W=470e-9 L=60e-9 MR=1
MNM_SE1 net18 S net51 VPW nm1p2_svt_lp W=470e-9 L=60e-9 MR=1
MNM3 net22 ckn net18 VPW nm1p2_svt_lp W=470e-9 L=60e-9 MR=1
MNM1 ckb ckn VSS VPW nm1p2_svt_lp W=470e-9 L=60e-9 MR=1
MNM0 ckn CK VSS VPW nm1p2_svt_lp W=470e-9 L=60e-9 MR=1
MPM11 Q net40 VDD VNW pm1p2_svt_lp W=2.36e-6 L=60e-9 MR=1
MPM10 net34 ckb net47 VNW pm1p2_svt_lp W=150e-9 L=60e-9 MR=1
MPM9 net47 net40 VDD VNW pm1p2_svt_lp W=150e-9 L=60e-9 MR=1
MPM8 net40 net34 VDD VNW pm1p2_svt_lp W=1.18e-6 L=60e-9 MR=1
MPM7 net34 ckn net31 VNW pm1p2_svt_lp W=590e-9 L=60e-9 MR=1
MPM6 net22 ckn net49 VNW pm1p2_svt_lp W=150e-9 L=60e-9 MR=1
MPM5 net49 net31 VDD VNW pm1p2_svt_lp W=150e-9 L=60e-9 MR=1
MPM4 net31 net22 VDD VNW pm1p2_svt_lp W=590e-9 L=60e-9 MR=1
MPM_SE0 sen S VDD VNW pm1p2_svt_lp W=300e-9 L=60e-9 MR=1
MPM3 net22 ckb net18 VNW pm1p2_svt_lp W=590e-9 L=60e-9 MR=1
MPMR2 net52 D1 VDD VNW pm1p2_svt_lp W=590e-9 L=60e-9 MR=1
MPML2 net53 D0 VDD VNW pm1p2_svt_lp W=590e-9 L=60e-9 MR=1
MPM_SE2 net18 S net52 VNW pm1p2_svt_lp W=590e-9 L=60e-9 MR=1
MPM_SE1 net18 sen net53 VNW pm1p2_svt_lp W=590e-9 L=60e-9 MR=1
MPM1 ckb ckn VDD VNW pm1p2_svt_lp W=590e-9 L=60e-9 MR=1
MPM0 ckn CK VDD VNW pm1p2_svt_lp W=390e-9 L=60e-9 MR=1
.ENDS
.SUBCKT EDFFQX0P5_9TSVT CK D E Q VDD VSS VNW VPW
MNM11 Q net37 VSS VPW nm1p2_svt_lp W=230e-9 L=60e-9 MR=1
MNM10 Q_BACK ckn net33 VPW nm1p2_svt_lp W=150e-9 L=60e-9 MR=1
MNM9 Q_BACK net37 VSS VPW nm1p2_svt_lp W=150e-9 L=60e-9 MR=1
MNM8 net37 net33 VSS VPW nm1p2_svt_lp W=230e-9 L=60e-9 MR=1
MNM7 net33 ckb net30 VPW nm1p2_svt_lp W=230e-9 L=60e-9 MR=1
MNM5 net48 net30 VSS VPW nm1p2_svt_lp W=150e-9 L=60e-9 MR=1
MNM6 net21 ckb net48 VPW nm1p2_svt_lp W=150e-9 L=60e-9 MR=1
MNM4 net30 net21 VSS VPW nm1p2_svt_lp W=230e-9 L=60e-9 MR=1
MNM_E0 EN E VSS VPW nm1p2_svt_lp W=230e-9 L=60e-9 MR=1
MNM_Q_BACK net50 Q_BACK VSS VPW nm1p2_svt_lp W=230e-9 L=60e-9 MR=1
MNM_E net51 D VSS VPW nm1p2_svt_lp W=230e-9 L=60e-9 MR=1
MNM_EN net17 EN net50 VPW nm1p2_svt_lp W=230e-9 L=60e-9 MR=1
MNM_D net17 E net51 VPW nm1p2_svt_lp W=230e-9 L=60e-9 MR=1
MNM2 net21 ckn net17 VPW nm1p2_svt_lp W=230e-9 L=60e-9 MR=1
MNM1 ckb ckn VSS VPW nm1p2_svt_lp W=230e-9 L=60e-9 MR=1
MNM0 ckn CK VSS VPW nm1p2_svt_lp W=230e-9 L=60e-9 MR=1
MPM11 Q net37 VDD VNW pm1p2_svt_lp W=300e-9 L=60e-9 MR=1
MPM10 Q_BACK ckb net33 VNW pm1p2_svt_lp W=150e-9 L=60e-9 MR=1
MPM9 Q_BACK net37 VDD VNW pm1p2_svt_lp W=150e-9 L=60e-9 MR=1
MPM8 net37 net33 VDD VNW pm1p2_svt_lp W=300e-9 L=60e-9 MR=1
MPM7 net33 ckn net30 VNW pm1p2_svt_lp W=300e-9 L=60e-9 MR=1
MPM6 net21 ckn net49 VNW pm1p2_svt_lp W=150e-9 L=60e-9 MR=1
MPM5 net49 net30 VDD VNW pm1p2_svt_lp W=150e-9 L=60e-9 MR=1
MPM4 net30 net21 VDD VNW pm1p2_svt_lp W=300e-9 L=60e-9 MR=1
MPM_E0 EN E VDD VNW pm1p2_svt_lp W=300e-9 L=60e-9 MR=1
MPM2 net21 ckb net17 VNW pm1p2_svt_lp W=300e-9 L=60e-9 MR=1
MPM_Q_BACK net52 Q_BACK VDD VNW pm1p2_svt_lp W=300e-9 L=60e-9 MR=1
MPM_EN net53 D VDD VNW pm1p2_svt_lp W=300e-9 L=60e-9 MR=1
MPM_E net17 E net52 VNW pm1p2_svt_lp W=300e-9 L=60e-9 MR=1
MPM_D net17 EN net53 VNW pm1p2_svt_lp W=300e-9 L=60e-9 MR=1
MPM1 ckb ckn VDD VNW pm1p2_svt_lp W=300e-9 L=60e-9 MR=1
MPM0 ckn CK VDD VNW pm1p2_svt_lp W=300e-9 L=60e-9 MR=1
.ENDS
.SUBCKT EDFFQX1_9TSVT CK D E Q VDD VSS VNW VPW
MNM11 Q net37 VSS VPW nm1p2_svt_lp W=470e-9 L=60e-9 MR=1
MNM10 Q_BACK ckn net33 VPW nm1p2_svt_lp W=150e-9 L=60e-9 MR=1
MNM9 Q_BACK net37 VSS VPW nm1p2_svt_lp W=150e-9 L=60e-9 MR=1
MNM8 net37 net33 VSS VPW nm1p2_svt_lp W=470e-9 L=60e-9 MR=1
MNM7 net33 ckb net30 VPW nm1p2_svt_lp W=230n L=60n MR=1
MNM5 net48 net30 VSS VPW nm1p2_svt_lp W=150e-9 L=60e-9 MR=1
MNM6 net21 ckb net48 VPW nm1p2_svt_lp W=150e-9 L=60e-9 MR=1
MNM4 net30 net21 VSS VPW nm1p2_svt_lp W=470e-9 L=60e-9 MR=1
MNM_E0 EN E VSS VPW nm1p2_svt_lp W=230e-9 L=60e-9 MR=1
MNM_Q_BACK net50 Q_BACK VSS VPW nm1p2_svt_lp W=230n L=60n MR=1
MNM_E net51 D VSS VPW nm1p2_svt_lp W=230n L=60n MR=1
MNM_EN net17 EN net50 VPW nm1p2_svt_lp W=230n L=60n MR=1
MNM_D net17 E net51 VPW nm1p2_svt_lp W=230n L=60n MR=1
MNM2 net21 ckn net17 VPW nm1p2_svt_lp W=230n L=60n MR=1
MNM1 ckb ckn VSS VPW nm1p2_svt_lp W=230e-9 L=60e-9 MR=1
MNM0 ckn CK VSS VPW nm1p2_svt_lp W=230e-9 L=60e-9 MR=1
MPM11 Q net37 VDD VNW pm1p2_svt_lp W=590e-9 L=60e-9 MR=1
MPM10 Q_BACK ckb net33 VNW pm1p2_svt_lp W=150e-9 L=60e-9 MR=1
MPM9 Q_BACK net37 VDD VNW pm1p2_svt_lp W=150e-9 L=60e-9 MR=1
MPM8 net37 net33 VDD VNW pm1p2_svt_lp W=590e-9 L=60e-9 MR=1
MPM7 net33 ckn net30 VNW pm1p2_svt_lp W=300n L=60n MR=1
MPM6 net21 ckn net49 VNW pm1p2_svt_lp W=150e-9 L=60e-9 MR=1
MPM5 net49 net30 VDD VNW pm1p2_svt_lp W=150e-9 L=60e-9 MR=1
MPM4 net30 net21 VDD VNW pm1p2_svt_lp W=390e-9 L=60e-9 MR=1
MPM_E0 EN E VDD VNW pm1p2_svt_lp W=300e-9 L=60e-9 MR=1
MPM2 net21 ckb net17 VNW pm1p2_svt_lp W=300n L=60n MR=1
MPM_Q_BACK net52 Q_BACK VDD VNW pm1p2_svt_lp W=300n L=60n MR=1
MPM_EN net53 D VDD VNW pm1p2_svt_lp W=300n L=60n MR=1
MPM_E net17 E net52 VNW pm1p2_svt_lp W=300n L=60n MR=1
MPM_D net17 EN net53 VNW pm1p2_svt_lp W=300n L=60n MR=1
MPM1 ckb ckn VDD VNW pm1p2_svt_lp W=300e-9 L=60e-9 MR=1
MPM0 ckn CK VDD VNW pm1p2_svt_lp W=300e-9 L=60e-9 MR=1
.ENDS
.SUBCKT EDFFQX2_9TSVT CK D E Q VDD VSS VNW VPW
MNM11 Q net37 VSS VPW nm1p2_svt_lp W=940e-9 L=60e-9 MR=1
MNM10 Q_BACK ckn net33 VPW nm1p2_svt_lp W=150e-9 L=60e-9 MR=1
MNM9 Q_BACK net37 VSS VPW nm1p2_svt_lp W=150e-9 L=60e-9 MR=1
MNM8 net37 net33 VSS VPW nm1p2_svt_lp W=470e-9 L=60e-9 MR=1
MNM7 net33 ckb net30 VPW nm1p2_svt_lp W=230n L=60n MR=1
MNM5 net48 net30 VSS VPW nm1p2_svt_lp W=150e-9 L=60e-9 MR=1
MNM6 net21 ckb net48 VPW nm1p2_svt_lp W=150e-9 L=60e-9 MR=1
MNM4 net30 net21 VSS VPW nm1p2_svt_lp W=470e-9 L=60e-9 MR=1
MNM_E0 EN E VSS VPW nm1p2_svt_lp W=230e-9 L=60e-9 MR=1
MNM_Q_BACK net50 Q_BACK VSS VPW nm1p2_svt_lp W=230n L=60n MR=1
MNM_E net51 D VSS VPW nm1p2_svt_lp W=470e-9 L=60e-9 MR=1
MNM_EN net17 EN net50 VPW nm1p2_svt_lp W=230n L=60n MR=1
MNM_D net17 E net51 VPW nm1p2_svt_lp W=470e-9 L=60e-9 MR=1
MNM2 net21 ckn net17 VPW nm1p2_svt_lp W=230n L=60n MR=1
MNM1 ckb ckn VSS VPW nm1p2_svt_lp W=230e-9 L=60e-9 MR=1
MNM0 ckn CK VSS VPW nm1p2_svt_lp W=230e-9 L=60e-9 MR=1
MPM11 Q net37 VDD VNW pm1p2_svt_lp W=1.18e-6 L=60e-9 MR=1
MPM10 Q_BACK ckb net33 VNW pm1p2_svt_lp W=150e-9 L=60e-9 MR=1
MPM9 Q_BACK net37 VDD VNW pm1p2_svt_lp W=150e-9 L=60e-9 MR=1
MPM8 net37 net33 VDD VNW pm1p2_svt_lp W=590e-9 L=60e-9 MR=1
MPM7 net33 ckn net30 VNW pm1p2_svt_lp W=300n L=60n MR=1
MPM6 net21 ckn net49 VNW pm1p2_svt_lp W=150e-9 L=60e-9 MR=1
MPM5 net49 net30 VDD VNW pm1p2_svt_lp W=150e-9 L=60e-9 MR=1
MPM4 net30 net21 VDD VNW pm1p2_svt_lp W=390e-9 L=60e-9 MR=1
MPM_E0 EN E VDD VNW pm1p2_svt_lp W=300e-9 L=60e-9 MR=1
MPM2 net21 ckb net17 VNW pm1p2_svt_lp W=300n L=60n MR=1
MPM_Q_BACK net52 Q_BACK VDD VNW pm1p2_svt_lp W=300n L=60n MR=1
MPM_EN net53 D VDD VNW pm1p2_svt_lp W=590e-9 L=60e-9 MR=1
MPM_E net17 E net52 VNW pm1p2_svt_lp W=300n L=60n MR=1
MPM_D net17 EN net53 VNW pm1p2_svt_lp W=590e-9 L=60e-9 MR=1
MPM1 ckb ckn VDD VNW pm1p2_svt_lp W=300e-9 L=60e-9 MR=1
MPM0 ckn CK VDD VNW pm1p2_svt_lp W=300e-9 L=60e-9 MR=1
.ENDS
.SUBCKT EDFFQX4_9TSVT CK D E Q VDD VSS VNW VPW
MNM11 Q net37 VSS VPW nm1p2_svt_lp W=1.88e-6 L=60e-9 MR=1
MNM10 Q_BACK ckn net33 VPW nm1p2_svt_lp W=150e-9 L=60e-9 MR=1
MNM9 Q_BACK net37 VSS VPW nm1p2_svt_lp W=150e-9 L=60e-9 MR=1
MNM8 net37 net33 VSS VPW nm1p2_svt_lp W=940e-9 L=60e-9 MR=1
MNM7 net33 ckb net30 VPW nm1p2_svt_lp W=230n L=60n MR=1
MNM5 net48 net30 VSS VPW nm1p2_svt_lp W=150e-9 L=60e-9 MR=1
MNM6 net21 ckb net48 VPW nm1p2_svt_lp W=150e-9 L=60e-9 MR=1
MNM4 net30 net21 VSS VPW nm1p2_svt_lp W=470e-9 L=60e-9 MR=1
MNM_E0 EN E VSS VPW nm1p2_svt_lp W=230e-9 L=60e-9 MR=1
MNM_Q_BACK net50 Q_BACK VSS VPW nm1p2_svt_lp W=230n L=60n MR=1
MNM_E net51 D VSS VPW nm1p2_svt_lp W=470e-9 L=60e-9 MR=1
MNM_EN net17 EN net50 VPW nm1p2_svt_lp W=230n L=60n MR=1
MNM_D net17 E net51 VPW nm1p2_svt_lp W=470e-9 L=60e-9 MR=1
MNM2 net21 ckn net17 VPW nm1p2_svt_lp W=230n L=60n MR=1
MNM1 ckb ckn VSS VPW nm1p2_svt_lp W=230n L=60n MR=1
MNM0 ckn CK VSS VPW nm1p2_svt_lp W=230n L=60n MR=1
MPM11 Q net37 VDD VNW pm1p2_svt_lp W=2.36e-6 L=60e-9 MR=1
MPM10 Q_BACK ckb net33 VNW pm1p2_svt_lp W=150e-9 L=60e-9 MR=1
MPM9 Q_BACK net37 VDD VNW pm1p2_svt_lp W=150e-9 L=60e-9 MR=1
MPM8 net37 net33 VDD VNW pm1p2_svt_lp W=1.18e-6 L=60e-9 MR=1
MPM7 net33 ckn net30 VNW pm1p2_svt_lp W=300n L=60n MR=1
MPM6 net21 ckn net49 VNW pm1p2_svt_lp W=150e-9 L=60e-9 MR=1
MPM5 net49 net30 VDD VNW pm1p2_svt_lp W=150e-9 L=60e-9 MR=1
MPM4 net30 net21 VDD VNW pm1p2_svt_lp W=390e-9 L=60e-9 MR=1
MPM_E0 EN E VDD VNW pm1p2_svt_lp W=300e-9 L=60e-9 MR=1
MPM2 net21 ckb net17 VNW pm1p2_svt_lp W=300n L=60n MR=1
MPM_Q_BACK net52 Q_BACK VDD VNW pm1p2_svt_lp W=300n L=60n MR=1
MPM_EN net53 D VDD VNW pm1p2_svt_lp W=590e-9 L=60e-9 MR=1
MPM_E net17 E net52 VNW pm1p2_svt_lp W=300n L=60n MR=1
MPM_D net17 EN net53 VNW pm1p2_svt_lp W=590e-9 L=60e-9 MR=1
MPM1 ckb ckn VDD VNW pm1p2_svt_lp W=300n L=60n MR=1
MPM0 ckn CK VDD VNW pm1p2_svt_lp W=300n L=60n MR=1
.ENDS
.SUBCKT FILL16_9TSVT VDD VSS VNW VPW
.ENDS
.SUBCKT FILL1_9TSVT VDD VSS VNW VPW
.ENDS
.SUBCKT FILL2_9TSVT VDD VSS VNW VPW
.ENDS
.SUBCKT FILL32_9TSVT VDD VSS VNW VPW
.ENDS
.SUBCKT FILL4_9TSVT VDD VSS VNW VPW
.ENDS
.SUBCKT FILL8_9TSVT VDD VSS VNW VPW
.ENDS
.SUBCKT FILLCAP16_9TSVT VDD VSS VNW VPW
MPM0 net4 net5 VDD VNW pm1p2_svt_lp W=4.72e-6 L=60e-9 MR=1
MNM0 net5 net4 VSS VPW nm1p2_svt_lp W=3.29e-6 L=60e-9 MR=1
.ENDS
.SUBCKT FILLCAP32_9TSVT VDD VSS VNW VPW
MPM0 net4 net5 VDD VNW pm1p2_svt_lp W=9.44e-6 L=60e-9 MR=1
MNM0 net5 net4 VSS VPW nm1p2_svt_lp W=7.05e-6 L=60e-9 MR=1
.ENDS
.SUBCKT FILLCAP4_9TSVT VDD VSS VNW VPW
MPM0 net4 net5 VDD VNW pm1p2_svt_lp W=590e-9 L=60e-9 MR=1
MNM0 net5 net4 VSS VPW nm1p2_svt_lp W=470e-9 L=60e-9 MR=1
.ENDS
.SUBCKT FILLCAP8_9TSVT VDD VSS VNW VPW
MPM0 net4 net5 VDD VNW pm1p2_svt_lp W=1.77e-6 L=60e-9 MR=1
MNM0 net5 net4 VSS VPW nm1p2_svt_lp W=1.41e-6 L=60e-9 MR=1
.ENDS
.SUBCKT INVX0P5_9TSVT A VDD VSS Y VNW VPW
MNM0 Y A VSS VPW nm1p2_svt_lp W=230e-9 L=60e-9 MR=1
MPM0 Y A VDD VNW pm1p2_svt_lp W=300e-9 L=60e-9 MR=1
.ENDS
.SUBCKT INVX10_9TSVT A VDD VSS Y VNW VPW
MNM0 Y A VSS VPW nm1p2_svt_lp W=4.7e-6 L=60e-9 MR=1
MPM0 Y A VDD VNW pm1p2_svt_lp W=5.9e-6 L=60e-9 MR=1
.ENDS
.SUBCKT INVX12_9TSVT A VDD VSS Y VNW VPW
MNM0 Y A VSS VPW nm1p2_svt_lp W=5.64e-6 L=60e-9 MR=1
MPM0 Y A VDD VNW pm1p2_svt_lp W=7.08e-6 L=60e-9 MR=1
.ENDS
.SUBCKT INVX16_9TSVT A VDD VSS Y VNW VPW
MNM0 Y A VSS VPW nm1p2_svt_lp W=7.52e-6 L=60e-9 MR=1
MPM0 Y A VDD VNW pm1p2_svt_lp W=9.44e-6 L=60e-9 MR=1
.ENDS
.SUBCKT INVX1_9TSVT A VDD VSS Y VNW VPW
MNM0 Y A VSS VPW nm1p2_svt_lp W=470e-9 L=60e-9 MR=1
MPM0 Y A VDD VNW pm1p2_svt_lp W=590e-9 L=60e-9 MR=1
.ENDS
.SUBCKT INVX24_9TSVT A VDD VSS Y VNW VPW
MNM0 Y A VSS VPW nm1p2_svt_lp W=11.28e-6 L=60e-9 MR=1
MPM0 Y A VDD VNW pm1p2_svt_lp W=14.16e-6 L=60e-9 MR=1
.ENDS
.SUBCKT INVX2_9TSVT A VDD VSS Y VNW VPW
MNM0 Y A VSS VPW nm1p2_svt_lp W=940e-9 L=60e-9 MR=1
MPM0 Y A VDD VNW pm1p2_svt_lp W=1.18e-6 L=60e-9 MR=1
.ENDS
.SUBCKT INVX3_9TSVT A VDD VSS Y VNW VPW
MNM0 Y A VSS VPW nm1p2_svt_lp W=1.41e-6 L=60e-9 MR=1
MPM0 Y A VDD VNW pm1p2_svt_lp W=1.77e-6 L=60e-9 MR=1
.ENDS
.SUBCKT INVX4_9TSVT A VDD VSS Y VNW VPW
MNM0 Y A VSS VPW nm1p2_svt_lp W=1.88e-6 L=60e-9 MR=1
MPM0 Y A VDD VNW pm1p2_svt_lp W=2.36e-6 L=60e-9 MR=1
.ENDS
.SUBCKT INVX5_9TSVT A VDD VSS Y VNW VPW
MNM0 Y A VSS VPW nm1p2_svt_lp W=2.35e-6 L=60e-9 MR=1
MPM0 Y A VDD VNW pm1p2_svt_lp W=2.95e-6 L=60e-9 MR=1
.ENDS
.SUBCKT INVX6_9TSVT A VDD VSS Y VNW VPW
MNM0 Y A VSS VPW nm1p2_svt_lp W=2.82e-6 L=60e-9 MR=1
MPM0 Y A VDD VNW pm1p2_svt_lp W=3.54e-6 L=60e-9 MR=1
.ENDS
.SUBCKT INVX8_9TSVT A VDD VSS Y VNW VPW
MNM0 Y A VSS VPW nm1p2_svt_lp W=3.76e-6 L=60e-9 MR=1
MPM0 Y A VDD VNW pm1p2_svt_lp W=4.72e-6 L=60e-9 MR=1
.ENDS
.SUBCKT LATNQX0P5_9TSVT CKN D Q VDD VSS VNW VPW
MNM8 Q net26 VSS VPW nm1p2_svt_lp W=230e-9 L=60e-9 MR=1
MNM7 net26 net23 VSS VPW nm1p2_svt_lp W=230e-9 L=60e-9 MR=1
MNM5 net31 net23 VSS VPW nm1p2_svt_lp W=150e-9 L=60e-9 MR=1
MNM6 net17 ckb net31 VPW nm1p2_svt_lp W=150e-9 L=60e-9 MR=1
MNM4 net23 net17 VSS VPW nm1p2_svt_lp W=230e-9 L=60e-9 MR=1
MNM2 net33 D VSS VPW nm1p2_svt_lp W=230e-9 L=60e-9 MR=1
MNM3 net17 cknn net33 VPW nm1p2_svt_lp W=230e-9 L=60e-9 MR=1
MNM1 ckb cknn VSS VPW nm1p2_svt_lp W=230e-9 L=60e-9 MR=1
MNM0 cknn CKN VSS VPW nm1p2_svt_lp W=230e-9 L=60e-9 MR=1
MPM8 Q net26 VDD VNW pm1p2_svt_lp W=300e-9 L=60e-9 MR=1
MPM7 net26 net23 VDD VNW pm1p2_svt_lp W=300e-9 L=60e-9 MR=1
MPM6 net17 cknn net32 VNW pm1p2_svt_lp W=150e-9 L=60e-9 MR=1
MPM5 net32 net23 VDD VNW pm1p2_svt_lp W=150e-9 L=60e-9 MR=1
MPM4 net23 net17 VDD VNW pm1p2_svt_lp W=300e-9 L=60e-9 MR=1
MPM3 net17 ckb net34 VNW pm1p2_svt_lp W=300e-9 L=60e-9 MR=1
MPM2 net34 D VDD VNW pm1p2_svt_lp W=300e-9 L=60e-9 MR=1
MPM1 ckb cknn VDD VNW pm1p2_svt_lp W=300e-9 L=60e-9 MR=1
MPM0 cknn CKN VDD VNW pm1p2_svt_lp W=300e-9 L=60e-9 MR=1
.ENDS
.SUBCKT LATNQX1_9TSVT CKN D Q VDD VSS VNW VPW
MNM8 Q net26 VSS VPW nm1p2_svt_lp W=470e-9 L=60e-9 MR=1
MNM7 net26 net23 VSS VPW nm1p2_svt_lp W=470e-9 L=60e-9 MR=1
MNM5 net31 net23 VSS VPW nm1p2_svt_lp W=150e-9 L=60e-9 MR=1
MNM6 net17 ckb net31 VPW nm1p2_svt_lp W=150e-9 L=60e-9 MR=1
MNM4 net23 net17 VSS VPW nm1p2_svt_lp W=470e-9 L=60e-9 MR=1
MNM2 net33 D VSS VPW nm1p2_svt_lp W=230n L=60n MR=1
MNM3 net17 cknn net33 VPW nm1p2_svt_lp W=230n L=60n MR=1
MNM1 ckb cknn VSS VPW nm1p2_svt_lp W=230e-9 L=60e-9 MR=1
MNM0 cknn CKN VSS VPW nm1p2_svt_lp W=230e-9 L=60e-9 MR=1
MPM8 Q net26 VDD VNW pm1p2_svt_lp W=590e-9 L=60e-9 MR=1
MPM7 net26 net23 VDD VNW pm1p2_svt_lp W=590e-9 L=60e-9 MR=1
MPM6 net17 cknn net32 VNW pm1p2_svt_lp W=150e-9 L=60e-9 MR=1
MPM5 net32 net23 VDD VNW pm1p2_svt_lp W=150e-9 L=60e-9 MR=1
MPM4 net23 net17 VDD VNW pm1p2_svt_lp W=590e-9 L=60e-9 MR=1
MPM3 net17 ckb net34 VNW pm1p2_svt_lp W=300n L=60n MR=1
MPM2 net34 D VDD VNW pm1p2_svt_lp W=300n L=60n MR=1
MPM1 ckb cknn VDD VNW pm1p2_svt_lp W=300e-9 L=60e-9 MR=1
MPM0 cknn CKN VDD VNW pm1p2_svt_lp W=300e-9 L=60e-9 MR=1
.ENDS
.SUBCKT LATNQX2_9TSVT CKN D Q VDD VSS VNW VPW
MNM8 Q net26 VSS VPW nm1p2_svt_lp W=940e-9 L=60e-9 MR=1
MNM7 net26 net23 VSS VPW nm1p2_svt_lp W=470e-9 L=60e-9 MR=1
MNM5 net31 net23 VSS VPW nm1p2_svt_lp W=150e-9 L=60e-9 MR=1
MNM6 net17 ckb net31 VPW nm1p2_svt_lp W=150e-9 L=60e-9 MR=1
MNM4 net23 net17 VSS VPW nm1p2_svt_lp W=470e-9 L=60e-9 MR=1
MNM2 net33 D VSS VPW nm1p2_svt_lp W=470e-9 L=60e-9 MR=1
MNM3 net17 cknn net33 VPW nm1p2_svt_lp W=470e-9 L=60e-9 MR=1
MNM1 ckb cknn VSS VPW nm1p2_svt_lp W=230e-9 L=60e-9 MR=1
MNM0 cknn CKN VSS VPW nm1p2_svt_lp W=230e-9 L=60e-9 MR=1
MPM8 Q net26 VDD VNW pm1p2_svt_lp W=1.18e-6 L=60e-9 MR=1
MPM7 net26 net23 VDD VNW pm1p2_svt_lp W=590e-9 L=60e-9 MR=1
MPM6 net17 cknn net32 VNW pm1p2_svt_lp W=150e-9 L=60e-9 MR=1
MPM5 net32 net23 VDD VNW pm1p2_svt_lp W=150e-9 L=60e-9 MR=1
MPM4 net23 net17 VDD VNW pm1p2_svt_lp W=590e-9 L=60e-9 MR=1
MPM3 net17 ckb net34 VNW pm1p2_svt_lp W=590e-9 L=60e-9 MR=1
MPM2 net34 D VDD VNW pm1p2_svt_lp W=590e-9 L=60e-9 MR=1
MPM1 ckb cknn VDD VNW pm1p2_svt_lp W=300e-9 L=60e-9 MR=1
MPM0 cknn CKN VDD VNW pm1p2_svt_lp W=300e-9 L=60e-9 MR=1
.ENDS
.SUBCKT LATNQX4_9TSVT CKN D Q VDD VSS VNW VPW
MNM8 Q net26 VSS VPW nm1p2_svt_lp W=1.88e-6 L=60e-9 MR=1
MNM7 net26 net23 VSS VPW nm1p2_svt_lp W=940e-9 L=60e-9 MR=1
MNM5 net31 net23 VSS VPW nm1p2_svt_lp W=150e-9 L=60e-9 MR=1
MNM6 net17 ckb net31 VPW nm1p2_svt_lp W=150e-9 L=60e-9 MR=1
MNM4 net23 net17 VSS VPW nm1p2_svt_lp W=470e-9 L=60e-9 MR=1
MNM2 net33 D VSS VPW nm1p2_svt_lp W=470e-9 L=60e-9 MR=1
MNM3 net17 cknn net33 VPW nm1p2_svt_lp W=470e-9 L=60e-9 MR=1
MNM1 ckb cknn VSS VPW nm1p2_svt_lp W=230n L=60n MR=1
MNM0 cknn CKN VSS VPW nm1p2_svt_lp W=230n L=60n MR=1
MPM8 Q net26 VDD VNW pm1p2_svt_lp W=2.36e-6 L=60e-9 MR=1
MPM7 net26 net23 VDD VNW pm1p2_svt_lp W=1.18e-6 L=60e-9 MR=1
MPM6 net17 cknn net32 VNW pm1p2_svt_lp W=150e-9 L=60e-9 MR=1
MPM5 net32 net23 VDD VNW pm1p2_svt_lp W=150e-9 L=60e-9 MR=1
MPM4 net23 net17 VDD VNW pm1p2_svt_lp W=590e-9 L=60e-9 MR=1
MPM3 net17 ckb net34 VNW pm1p2_svt_lp W=590e-9 L=60e-9 MR=1
MPM2 net34 D VDD VNW pm1p2_svt_lp W=590e-9 L=60e-9 MR=1
MPM1 ckb cknn VDD VNW pm1p2_svt_lp W=300n L=60n MR=1
MPM0 cknn CKN VDD VNW pm1p2_svt_lp W=300n L=60n MR=1
.ENDS
.SUBCKT LATNRNQX0P5_9TSVT CKN D Q RN VDD VSS VNW VPW
MNM8 Q net27 VSS VPW nm1p2_svt_lp W=230e-9 L=60e-9 MR=1
MNM7 net27 net24 VSS VPW nm1p2_svt_lp W=230e-9 L=60e-9 MR=1
MNM_RN net32 RN VSS VPW nm1p2_svt_lp W=150e-9 L=60e-9 MR=1
MNM5 net33 net24 net32 VPW nm1p2_svt_lp W=150e-9 L=60e-9 MR=1
MNM6 net15 ckb net33 VPW nm1p2_svt_lp W=150e-9 L=60e-9 MR=1
MNM4 net24 net15 VSS VPW nm1p2_svt_lp W=230e-9 L=60e-9 MR=1
MNM0_RN net35 RN VSS VPW nm1p2_svt_lp W=230e-9 L=60e-9 MR=1
MNM2 net36 D net35 VPW nm1p2_svt_lp W=230e-9 L=60e-9 MR=1
MNM3 net15 cknn net36 VPW nm1p2_svt_lp W=230e-9 L=60e-9 MR=1
MNM1 ckb cknn VSS VPW nm1p2_svt_lp W=230e-9 L=60e-9 MR=1
MNM0 cknn CKN VSS VPW nm1p2_svt_lp W=230e-9 L=60e-9 MR=1
MPM8 Q net27 VDD VNW pm1p2_svt_lp W=300e-9 L=60e-9 MR=1
MPM7 net27 net24 VDD VNW pm1p2_svt_lp W=300e-9 L=60e-9 MR=1
MPM6 net15 cknn net34 VNW pm1p2_svt_lp W=150e-9 L=60e-9 MR=1
MPM5 net34 net24 VDD VNW pm1p2_svt_lp W=150e-9 L=60e-9 MR=1
MPM4 net24 net15 VDD VNW pm1p2_svt_lp W=300e-9 L=60e-9 MR=1
MPM3 net15 ckb net37 VNW pm1p2_svt_lp W=300e-9 L=60e-9 MR=1
MPM0_RN net15 RN VDD VNW pm1p2_svt_lp W=300e-9 L=60e-9 MR=1
MPM2 net37 D VDD VNW pm1p2_svt_lp W=300e-9 L=60e-9 MR=1
MPM1 ckb cknn VDD VNW pm1p2_svt_lp W=300e-9 L=60e-9 MR=1
MPM0 cknn CKN VDD VNW pm1p2_svt_lp W=300e-9 L=60e-9 MR=1
.ENDS
.SUBCKT LATNRNQX1_9TSVT CKN D Q RN VDD VSS VNW VPW
MNM8 Q net27 VSS VPW nm1p2_svt_lp W=470e-9 L=60e-9 MR=1
MNM7 net27 net24 VSS VPW nm1p2_svt_lp W=470e-9 L=60e-9 MR=1
MNM_RN net32 RN VSS VPW nm1p2_svt_lp W=150e-9 L=60e-9 MR=1
MNM5 net33 net24 net32 VPW nm1p2_svt_lp W=150e-9 L=60e-9 MR=1
MNM6 net15 ckb net33 VPW nm1p2_svt_lp W=150e-9 L=60e-9 MR=1
MNM4 net24 net15 VSS VPW nm1p2_svt_lp W=470e-9 L=60e-9 MR=1
MNM0_RN net35 RN VSS VPW nm1p2_svt_lp W=230n L=60n MR=1
MNM2 net36 D net35 VPW nm1p2_svt_lp W=230n L=60n MR=1
MNM3 net15 cknn net36 VPW nm1p2_svt_lp W=230n L=60n MR=1
MNM1 ckb cknn VSS VPW nm1p2_svt_lp W=230e-9 L=60e-9 MR=1
MNM0 cknn CKN VSS VPW nm1p2_svt_lp W=230e-9 L=60e-9 MR=1
MPM8 Q net27 VDD VNW pm1p2_svt_lp W=590e-9 L=60e-9 MR=1
MPM7 net27 net24 VDD VNW pm1p2_svt_lp W=590e-9 L=60e-9 MR=1
MPM6 net15 cknn net34 VNW pm1p2_svt_lp W=150e-9 L=60e-9 MR=1
MPM5 net34 net24 VDD VNW pm1p2_svt_lp W=150e-9 L=60e-9 MR=1
MPM4 net24 net15 VDD VNW pm1p2_svt_lp W=590e-9 L=60e-9 MR=1
MPM3 net15 ckb net37 VNW pm1p2_svt_lp W=300n L=60n MR=1
MPM0_RN net15 RN VDD VNW pm1p2_svt_lp W=300n L=60n MR=1
MPM2 net37 D VDD VNW pm1p2_svt_lp W=300n L=60n MR=1
MPM1 ckb cknn VDD VNW pm1p2_svt_lp W=300e-9 L=60e-9 MR=1
MPM0 cknn CKN VDD VNW pm1p2_svt_lp W=300e-9 L=60e-9 MR=1
.ENDS
.SUBCKT LATNRNQX2_9TSVT CKN D Q RN VDD VSS VNW VPW
MNM8 Q net27 VSS VPW nm1p2_svt_lp W=940e-9 L=60e-9 MR=1
MNM7 net27 net24 VSS VPW nm1p2_svt_lp W=470e-9 L=60e-9 MR=1
MNM_RN net32 RN VSS VPW nm1p2_svt_lp W=150e-9 L=60e-9 MR=1
MNM5 net33 net24 net32 VPW nm1p2_svt_lp W=150e-9 L=60e-9 MR=1
MNM6 net15 ckb net33 VPW nm1p2_svt_lp W=150e-9 L=60e-9 MR=1
MNM4 net24 net15 VSS VPW nm1p2_svt_lp W=470e-9 L=60e-9 MR=1
MNM0_RN net35 RN VSS VPW nm1p2_svt_lp W=470e-9 L=60e-9 MR=1
MNM2 net36 D net35 VPW nm1p2_svt_lp W=470e-9 L=60e-9 MR=1
MNM3 net15 cknn net36 VPW nm1p2_svt_lp W=470e-9 L=60e-9 MR=1
MNM1 ckb cknn VSS VPW nm1p2_svt_lp W=230e-9 L=60e-9 MR=1
MNM0 cknn CKN VSS VPW nm1p2_svt_lp W=230e-9 L=60e-9 MR=1
MPM8 Q net27 VDD VNW pm1p2_svt_lp W=1.18e-6 L=60e-9 MR=1
MPM7 net27 net24 VDD VNW pm1p2_svt_lp W=590e-9 L=60e-9 MR=1
MPM6 net15 cknn net34 VNW pm1p2_svt_lp W=150e-9 L=60e-9 MR=1
MPM5 net34 net24 VDD VNW pm1p2_svt_lp W=150e-9 L=60e-9 MR=1
MPM4 net24 net15 VDD VNW pm1p2_svt_lp W=590e-9 L=60e-9 MR=1
MPM3 net15 ckb net37 VNW pm1p2_svt_lp W=590e-9 L=60e-9 MR=1
MPM0_RN net15 RN VDD VNW pm1p2_svt_lp W=590e-9 L=60e-9 MR=1
MPM2 net37 D VDD VNW pm1p2_svt_lp W=590e-9 L=60e-9 MR=1
MPM1 ckb cknn VDD VNW pm1p2_svt_lp W=300e-9 L=60e-9 MR=1
MPM0 cknn CKN VDD VNW pm1p2_svt_lp W=300e-9 L=60e-9 MR=1
.ENDS
.SUBCKT LATNRNQX4_9TSVT CKN D Q RN VDD VSS VNW VPW
MNM8 Q net27 VSS VPW nm1p2_svt_lp W=1.88e-6 L=60e-9 MR=1
MNM7 net27 net24 VSS VPW nm1p2_svt_lp W=940e-9 L=60e-9 MR=1
MNM_RN net32 RN VSS VPW nm1p2_svt_lp W=150e-9 L=60e-9 MR=1
MNM5 net33 net24 net32 VPW nm1p2_svt_lp W=150e-9 L=60e-9 MR=1
MNM6 net15 ckb net33 VPW nm1p2_svt_lp W=150e-9 L=60e-9 MR=1
MNM4 net24 net15 VSS VPW nm1p2_svt_lp W=470e-9 L=60e-9 MR=1
MNM0_RN net35 RN VSS VPW nm1p2_svt_lp W=470e-9 L=60e-9 MR=1
MNM2 net36 D net35 VPW nm1p2_svt_lp W=470e-9 L=60e-9 MR=1
MNM3 net15 cknn net36 VPW nm1p2_svt_lp W=470e-9 L=60e-9 MR=1
MNM1 ckb cknn VSS VPW nm1p2_svt_lp W=230n L=60n MR=1
MNM0 cknn CKN VSS VPW nm1p2_svt_lp W=230n L=60n MR=1
MPM8 Q net27 VDD VNW pm1p2_svt_lp W=2.36e-6 L=60e-9 MR=1
MPM7 net27 net24 VDD VNW pm1p2_svt_lp W=1.18e-6 L=60e-9 MR=1
MPM6 net15 cknn net34 VNW pm1p2_svt_lp W=150e-9 L=60e-9 MR=1
MPM5 net34 net24 VDD VNW pm1p2_svt_lp W=150e-9 L=60e-9 MR=1
MPM4 net24 net15 VDD VNW pm1p2_svt_lp W=590e-9 L=60e-9 MR=1
MPM3 net15 ckb net37 VNW pm1p2_svt_lp W=590e-9 L=60e-9 MR=1
MPM0_RN net15 RN VDD VNW pm1p2_svt_lp W=590e-9 L=60e-9 MR=1
MPM2 net37 D VDD VNW pm1p2_svt_lp W=590e-9 L=60e-9 MR=1
MPM1 ckb cknn VDD VNW pm1p2_svt_lp W=300n L=60n MR=1
MPM0 cknn CKN VDD VNW pm1p2_svt_lp W=300n L=60n MR=1
.ENDS
.SUBCKT LATNRSNQX0P5_9TSVT CKN D Q RN SN VDD VSS VNW VPW
MNM8 Q net28 VSS VPW nm1p2_svt_lp W=230e-9 L=60e-9 MR=1
MNM7 net28 net23 VSS VPW nm1p2_svt_lp W=230e-9 L=60e-9 MR=1
MNM_RN net35 RN VSS VPW nm1p2_svt_lp W=150e-9 L=60e-9 MR=1
MNM5 net36 net23 net35 VPW nm1p2_svt_lp W=150e-9 L=60e-9 MR=1
MNM6 net17 ckb net36 VPW nm1p2_svt_lp W=150e-9 L=60e-9 MR=1
MNM4 net38 net17 VSS VPW nm1p2_svt_lp W=230e-9 L=60e-9 MR=1
MNM_SN net23 SN net38 VPW nm1p2_svt_lp W=230e-9 L=60e-9 MR=1
MNM0_RN net39 RN VSS VPW nm1p2_svt_lp W=230e-9 L=60e-9 MR=1
MNM2 net40 D net39 VPW nm1p2_svt_lp W=230e-9 L=60e-9 MR=1
MNM3 net17 cknn net40 VPW nm1p2_svt_lp W=230e-9 L=60e-9 MR=1
MNM1 ckb cknn VSS VPW nm1p2_svt_lp W=230e-9 L=60e-9 MR=1
MNM0 cknn CKN VSS VPW nm1p2_svt_lp W=230e-9 L=60e-9 MR=1
MPM8 Q net28 VDD VNW pm1p2_svt_lp W=300e-9 L=60e-9 MR=1
MPM7 net28 net23 VDD VNW pm1p2_svt_lp W=300e-9 L=60e-9 MR=1
MPM6 net17 cknn net37 VNW pm1p2_svt_lp W=150e-9 L=60e-9 MR=1
MPM5 net37 net23 VDD VNW pm1p2_svt_lp W=150e-9 L=60e-9 MR=1
MPM_SN net23 SN VDD VNW pm1p2_svt_lp W=300e-9 L=60e-9 MR=1
MPM4 net23 net17 VDD VNW pm1p2_svt_lp W=300e-9 L=60e-9 MR=1
MPM3 net17 ckb net41 VNW pm1p2_svt_lp W=300e-9 L=60e-9 MR=1
MPM0_RN net17 RN VDD VNW pm1p2_svt_lp W=300e-9 L=60e-9 MR=1
MPM2 net41 D VDD VNW pm1p2_svt_lp W=300e-9 L=60e-9 MR=1
MPM1 ckb cknn VDD VNW pm1p2_svt_lp W=300e-9 L=60e-9 MR=1
MPM0 cknn CKN VDD VNW pm1p2_svt_lp W=300e-9 L=60e-9 MR=1
.ENDS
.SUBCKT LATNRSNQX1_9TSVT CKN D Q RN SN VDD VSS VNW VPW
MNM8 Q net28 VSS VPW nm1p2_svt_lp W=470e-9 L=60e-9 MR=1
MNM7 net28 net23 VSS VPW nm1p2_svt_lp W=470e-9 L=60e-9 MR=1
MNM_RN net35 RN VSS VPW nm1p2_svt_lp W=150e-9 L=60e-9 MR=1
MNM5 net36 net23 net35 VPW nm1p2_svt_lp W=150e-9 L=60e-9 MR=1
MNM6 net17 ckb net36 VPW nm1p2_svt_lp W=150e-9 L=60e-9 MR=1
MNM4 net38 net17 VSS VPW nm1p2_svt_lp W=470e-9 L=60e-9 MR=1
MNM_SN net23 SN net38 VPW nm1p2_svt_lp W=470e-9 L=60e-9 MR=1
MNM0_RN net39 RN VSS VPW nm1p2_svt_lp W=230n L=60n MR=1
MNM2 net40 D net39 VPW nm1p2_svt_lp W=230n L=60n MR=1
MNM3 net17 cknn net40 VPW nm1p2_svt_lp W=230n L=60n MR=1
MNM1 ckb cknn VSS VPW nm1p2_svt_lp W=230e-9 L=60e-9 MR=1
MNM0 cknn CKN VSS VPW nm1p2_svt_lp W=230e-9 L=60e-9 MR=1
MPM8 Q net28 VDD VNW pm1p2_svt_lp W=590e-9 L=60e-9 MR=1
MPM7 net28 net23 VDD VNW pm1p2_svt_lp W=590e-9 L=60e-9 MR=1
MPM6 net17 cknn net37 VNW pm1p2_svt_lp W=150e-9 L=60e-9 MR=1
MPM5 net37 net23 VDD VNW pm1p2_svt_lp W=150e-9 L=60e-9 MR=1
MPM_SN net23 SN VDD VNW pm1p2_svt_lp W=590e-9 L=60e-9 MR=1
MPM4 net23 net17 VDD VNW pm1p2_svt_lp W=590e-9 L=60e-9 MR=1
MPM3 net17 ckb net41 VNW pm1p2_svt_lp W=300n L=60n MR=1
MPM0_RN net17 RN VDD VNW pm1p2_svt_lp W=300n L=60n MR=1
MPM2 net41 D VDD VNW pm1p2_svt_lp W=300n L=60n MR=1
MPM1 ckb cknn VDD VNW pm1p2_svt_lp W=300e-9 L=60e-9 MR=1
MPM0 cknn CKN VDD VNW pm1p2_svt_lp W=300e-9 L=60e-9 MR=1
.ENDS
.SUBCKT LATNRSNQX2_9TSVT CKN D Q RN SN VDD VSS VNW VPW
MNM8 Q net28 VSS VPW nm1p2_svt_lp W=940e-9 L=60e-9 MR=1
MNM7 net28 net23 VSS VPW nm1p2_svt_lp W=470e-9 L=60e-9 MR=1
MNM_RN net35 RN VSS VPW nm1p2_svt_lp W=150e-9 L=60e-9 MR=1
MNM5 net36 net23 net35 VPW nm1p2_svt_lp W=150e-9 L=60e-9 MR=1
MNM6 net17 ckb net36 VPW nm1p2_svt_lp W=150e-9 L=60e-9 MR=1
MNM4 net38 net17 VSS VPW nm1p2_svt_lp W=470e-9 L=60e-9 MR=1
MNM_SN net23 SN net38 VPW nm1p2_svt_lp W=470e-9 L=60e-9 MR=1
MNM0_RN net39 RN VSS VPW nm1p2_svt_lp W=470e-9 L=60e-9 MR=1
MNM2 net40 D net39 VPW nm1p2_svt_lp W=470e-9 L=60e-9 MR=1
MNM3 net17 cknn net40 VPW nm1p2_svt_lp W=470e-9 L=60e-9 MR=1
MNM1 ckb cknn VSS VPW nm1p2_svt_lp W=230e-9 L=60e-9 MR=1
MNM0 cknn CKN VSS VPW nm1p2_svt_lp W=230e-9 L=60e-9 MR=1
MPM8 Q net28 VDD VNW pm1p2_svt_lp W=1.18e-6 L=60e-9 MR=1
MPM7 net28 net23 VDD VNW pm1p2_svt_lp W=590e-9 L=60e-9 MR=1
MPM6 net17 cknn net37 VNW pm1p2_svt_lp W=150e-9 L=60e-9 MR=1
MPM5 net37 net23 VDD VNW pm1p2_svt_lp W=150e-9 L=60e-9 MR=1
MPM_SN net23 SN VDD VNW pm1p2_svt_lp W=590e-9 L=60e-9 MR=1
MPM4 net23 net17 VDD VNW pm1p2_svt_lp W=590e-9 L=60e-9 MR=1
MPM3 net17 ckb net41 VNW pm1p2_svt_lp W=590e-9 L=60e-9 MR=1
MPM0_RN net17 RN VDD VNW pm1p2_svt_lp W=590e-9 L=60e-9 MR=1
MPM2 net41 D VDD VNW pm1p2_svt_lp W=590e-9 L=60e-9 MR=1
MPM1 ckb cknn VDD VNW pm1p2_svt_lp W=300e-9 L=60e-9 MR=1
MPM0 cknn CKN VDD VNW pm1p2_svt_lp W=300e-9 L=60e-9 MR=1
.ENDS
.SUBCKT LATNRSNQX4_9TSVT CKN D Q RN SN VDD VSS VNW VPW
MNM8 Q net28 VSS VPW nm1p2_svt_lp W=1.88e-6 L=60e-9 MR=1
MNM7 net28 net23 VSS VPW nm1p2_svt_lp W=940e-9 L=60e-9 MR=1
MNM_RN net35 RN VSS VPW nm1p2_svt_lp W=150e-9 L=60e-9 MR=1
MNM5 net36 net23 net35 VPW nm1p2_svt_lp W=150e-9 L=60e-9 MR=1
MNM6 net17 ckb net36 VPW nm1p2_svt_lp W=150e-9 L=60e-9 MR=1
MNM4 net38 net17 VSS VPW nm1p2_svt_lp W=470e-9 L=60e-9 MR=1
MNM_SN net23 SN net38 VPW nm1p2_svt_lp W=470e-9 L=60e-9 MR=1
MNM0_RN net39 RN VSS VPW nm1p2_svt_lp W=470e-9 L=60e-9 MR=1
MNM2 net40 D net39 VPW nm1p2_svt_lp W=470e-9 L=60e-9 MR=1
MNM3 net17 cknn net40 VPW nm1p2_svt_lp W=470e-9 L=60e-9 MR=1
MNM1 ckb cknn VSS VPW nm1p2_svt_lp W=230n L=60n MR=1
MNM0 cknn CKN VSS VPW nm1p2_svt_lp W=230n L=60n MR=1
MPM8 Q net28 VDD VNW pm1p2_svt_lp W=2.36e-6 L=60e-9 MR=1
MPM7 net28 net23 VDD VNW pm1p2_svt_lp W=1.18e-6 L=60e-9 MR=1
MPM6 net17 cknn net37 VNW pm1p2_svt_lp W=150e-9 L=60e-9 MR=1
MPM5 net37 net23 VDD VNW pm1p2_svt_lp W=150e-9 L=60e-9 MR=1
MPM_SN net23 SN VDD VNW pm1p2_svt_lp W=590e-9 L=60e-9 MR=1
MPM4 net23 net17 VDD VNW pm1p2_svt_lp W=590e-9 L=60e-9 MR=1
MPM3 net17 ckb net41 VNW pm1p2_svt_lp W=590e-9 L=60e-9 MR=1
MPM0_RN net17 RN VDD VNW pm1p2_svt_lp W=590e-9 L=60e-9 MR=1
MPM2 net41 D VDD VNW pm1p2_svt_lp W=590e-9 L=60e-9 MR=1
MPM1 ckb cknn VDD VNW pm1p2_svt_lp W=300n L=60n MR=1
MPM0 cknn CKN VDD VNW pm1p2_svt_lp W=300n L=60n MR=1
.ENDS
.SUBCKT LATNSNQX0P5_9TSVT CKN D Q SN VDD VSS VNW VPW
MNM8 Q net27 VSS VPW nm1p2_svt_lp W=230e-9 L=60e-9 MR=1
MNM7 net27 net22 VSS VPW nm1p2_svt_lp W=230e-9 L=60e-9 MR=1
MNM5 net34 net22 VSS VPW nm1p2_svt_lp W=150e-9 L=60e-9 MR=1
MNM6 net19 ckb net34 VPW nm1p2_svt_lp W=150e-9 L=60e-9 MR=1
MNM4 net36 net19 VSS VPW nm1p2_svt_lp W=230e-9 L=60e-9 MR=1
MNM_SN net22 SN net36 VPW nm1p2_svt_lp W=230e-9 L=60e-9 MR=1
MNM2 net37 D VSS VPW nm1p2_svt_lp W=230e-9 L=60e-9 MR=1
MNM3 net19 cknn net37 VPW nm1p2_svt_lp W=230e-9 L=60e-9 MR=1
MNM1 ckb cknn VSS VPW nm1p2_svt_lp W=230e-9 L=60e-9 MR=1
MNM0 cknn CKN VSS VPW nm1p2_svt_lp W=230e-9 L=60e-9 MR=1
MPM8 Q net27 VDD VNW pm1p2_svt_lp W=300e-9 L=60e-9 MR=1
MPM7 net27 net22 VDD VNW pm1p2_svt_lp W=300e-9 L=60e-9 MR=1
MPM6 net19 cknn net35 VNW pm1p2_svt_lp W=150e-9 L=60e-9 MR=1
MPM5 net35 net22 VDD VNW pm1p2_svt_lp W=150e-9 L=60e-9 MR=1
MPM_SN net22 SN VDD VNW pm1p2_svt_lp W=300e-9 L=60e-9 MR=1
MPM4 net22 net19 VDD VNW pm1p2_svt_lp W=300e-9 L=60e-9 MR=1
MPM3 net19 ckb net38 VNW pm1p2_svt_lp W=300e-9 L=60e-9 MR=1
MPM2 net38 D VDD VNW pm1p2_svt_lp W=300e-9 L=60e-9 MR=1
MPM1 ckb cknn VDD VNW pm1p2_svt_lp W=300e-9 L=60e-9 MR=1
MPM0 cknn CKN VDD VNW pm1p2_svt_lp W=300e-9 L=60e-9 MR=1
.ENDS
.SUBCKT LATNSNQX1_9TSVT CKN D Q SN VDD VSS VNW VPW
MNM8 Q net27 VSS VPW nm1p2_svt_lp W=470e-9 L=60e-9 MR=1
MNM7 net27 net22 VSS VPW nm1p2_svt_lp W=470e-9 L=60e-9 MR=1
MNM5 net34 net22 VSS VPW nm1p2_svt_lp W=150e-9 L=60e-9 MR=1
MNM6 net19 ckb net34 VPW nm1p2_svt_lp W=150e-9 L=60e-9 MR=1
MNM4 net36 net19 VSS VPW nm1p2_svt_lp W=470e-9 L=60e-9 MR=1
MNM_SN net22 SN net36 VPW nm1p2_svt_lp W=470e-9 L=60e-9 MR=1
MNM2 net37 D VSS VPW nm1p2_svt_lp W=230n L=60n MR=1
MNM3 net19 cknn net37 VPW nm1p2_svt_lp W=230n L=60n MR=1
MNM1 ckb cknn VSS VPW nm1p2_svt_lp W=230e-9 L=60e-9 MR=1
MNM0 cknn CKN VSS VPW nm1p2_svt_lp W=230e-9 L=60e-9 MR=1
MPM8 Q net27 VDD VNW pm1p2_svt_lp W=590e-9 L=60e-9 MR=1
MPM7 net27 net22 VDD VNW pm1p2_svt_lp W=590e-9 L=60e-9 MR=1
MPM6 net19 cknn net35 VNW pm1p2_svt_lp W=150e-9 L=60e-9 MR=1
MPM5 net35 net22 VDD VNW pm1p2_svt_lp W=150e-9 L=60e-9 MR=1
MPM_SN net22 SN VDD VNW pm1p2_svt_lp W=590e-9 L=60e-9 MR=1
MPM4 net22 net19 VDD VNW pm1p2_svt_lp W=590e-9 L=60e-9 MR=1
MPM3 net19 ckb net38 VNW pm1p2_svt_lp W=300n L=60n MR=1
MPM2 net38 D VDD VNW pm1p2_svt_lp W=300n L=60n MR=1
MPM1 ckb cknn VDD VNW pm1p2_svt_lp W=300e-9 L=60e-9 MR=1
MPM0 cknn CKN VDD VNW pm1p2_svt_lp W=300e-9 L=60e-9 MR=1
.ENDS
.SUBCKT LATNSNQX2_9TSVT CKN D Q SN VDD VSS VNW VPW
MNM8 Q net27 VSS VPW nm1p2_svt_lp W=940e-9 L=60e-9 MR=1
MNM7 net27 net22 VSS VPW nm1p2_svt_lp W=470e-9 L=60e-9 MR=1
MNM5 net34 net22 VSS VPW nm1p2_svt_lp W=150e-9 L=60e-9 MR=1
MNM6 net19 ckb net34 VPW nm1p2_svt_lp W=150e-9 L=60e-9 MR=1
MNM4 net36 net19 VSS VPW nm1p2_svt_lp W=470e-9 L=60e-9 MR=1
MNM_SN net22 SN net36 VPW nm1p2_svt_lp W=470e-9 L=60e-9 MR=1
MNM2 net37 D VSS VPW nm1p2_svt_lp W=470e-9 L=60e-9 MR=1
MNM3 net19 cknn net37 VPW nm1p2_svt_lp W=470e-9 L=60e-9 MR=1
MNM1 ckb cknn VSS VPW nm1p2_svt_lp W=230e-9 L=60e-9 MR=1
MNM0 cknn CKN VSS VPW nm1p2_svt_lp W=230e-9 L=60e-9 MR=1
MPM8 Q net27 VDD VNW pm1p2_svt_lp W=1.18e-6 L=60e-9 MR=1
MPM7 net27 net22 VDD VNW pm1p2_svt_lp W=590e-9 L=60e-9 MR=1
MPM6 net19 cknn net35 VNW pm1p2_svt_lp W=150e-9 L=60e-9 MR=1
MPM5 net35 net22 VDD VNW pm1p2_svt_lp W=150e-9 L=60e-9 MR=1
MPM_SN net22 SN VDD VNW pm1p2_svt_lp W=590e-9 L=60e-9 MR=1
MPM4 net22 net19 VDD VNW pm1p2_svt_lp W=590e-9 L=60e-9 MR=1
MPM3 net19 ckb net38 VNW pm1p2_svt_lp W=590e-9 L=60e-9 MR=1
MPM2 net38 D VDD VNW pm1p2_svt_lp W=590e-9 L=60e-9 MR=1
MPM1 ckb cknn VDD VNW pm1p2_svt_lp W=300e-9 L=60e-9 MR=1
MPM0 cknn CKN VDD VNW pm1p2_svt_lp W=300e-9 L=60e-9 MR=1
.ENDS
.SUBCKT LATNSNQX4_9TSVT CKN D Q SN VDD VSS VNW VPW
MNM8 Q net27 VSS VPW nm1p2_svt_lp W=1.88e-6 L=60e-9 MR=1
MNM7 net27 net22 VSS VPW nm1p2_svt_lp W=940e-9 L=60e-9 MR=1
MNM5 net34 net22 VSS VPW nm1p2_svt_lp W=150e-9 L=60e-9 MR=1
MNM6 net19 ckb net34 VPW nm1p2_svt_lp W=150e-9 L=60e-9 MR=1
MNM4 net36 net19 VSS VPW nm1p2_svt_lp W=470e-9 L=60e-9 MR=1
MNM_SN net22 SN net36 VPW nm1p2_svt_lp W=470e-9 L=60e-9 MR=1
MNM2 net37 D VSS VPW nm1p2_svt_lp W=470e-9 L=60e-9 MR=1
MNM3 net19 cknn net37 VPW nm1p2_svt_lp W=470e-9 L=60e-9 MR=1
MNM1 ckb cknn VSS VPW nm1p2_svt_lp W=230n L=60n MR=1
MNM0 cknn CKN VSS VPW nm1p2_svt_lp W=230n L=60n MR=1
MPM8 Q net27 VDD VNW pm1p2_svt_lp W=2.36e-6 L=60e-9 MR=1
MPM7 net27 net22 VDD VNW pm1p2_svt_lp W=1.18e-6 L=60e-9 MR=1
MPM6 net19 cknn net35 VNW pm1p2_svt_lp W=150e-9 L=60e-9 MR=1
MPM5 net35 net22 VDD VNW pm1p2_svt_lp W=150e-9 L=60e-9 MR=1
MPM_SN net22 SN VDD VNW pm1p2_svt_lp W=590e-9 L=60e-9 MR=1
MPM4 net22 net19 VDD VNW pm1p2_svt_lp W=590e-9 L=60e-9 MR=1
MPM3 net19 ckb net38 VNW pm1p2_svt_lp W=590e-9 L=60e-9 MR=1
MPM2 net38 D VDD VNW pm1p2_svt_lp W=590e-9 L=60e-9 MR=1
MPM1 ckb cknn VDD VNW pm1p2_svt_lp W=300n L=60n MR=1
MPM0 cknn CKN VDD VNW pm1p2_svt_lp W=300n L=60n MR=1
.ENDS
.SUBCKT LATQX0P5_9TSVT CK D Q VDD VSS VNW VPW
MNM8 Q net26 VSS VPW nm1p2_svt_lp W=230e-9 L=60e-9 MR=1
MNM7 net26 net23 VSS VPW nm1p2_svt_lp W=230e-9 L=60e-9 MR=1
MNM5 net31 net23 VSS VPW nm1p2_svt_lp W=150e-9 L=60e-9 MR=1
MNM6 net17 ckn net31 VPW nm1p2_svt_lp W=150e-9 L=60e-9 MR=1
MNM4 net23 net17 VSS VPW nm1p2_svt_lp W=230e-9 L=60e-9 MR=1
MNM2 net33 D VSS VPW nm1p2_svt_lp W=230e-9 L=60e-9 MR=1
MNM3 net17 ckb net33 VPW nm1p2_svt_lp W=230e-9 L=60e-9 MR=1
MNM1 ckb ckn VSS VPW nm1p2_svt_lp W=230e-9 L=60e-9 MR=1
MNM0 ckn CK VSS VPW nm1p2_svt_lp W=230e-9 L=60e-9 MR=1
MPM8 Q net26 VDD VNW pm1p2_svt_lp W=300e-9 L=60e-9 MR=1
MPM7 net26 net23 VDD VNW pm1p2_svt_lp W=300e-9 L=60e-9 MR=1
MPM6 net17 ckb net32 VNW pm1p2_svt_lp W=150e-9 L=60e-9 MR=1
MPM5 net32 net23 VDD VNW pm1p2_svt_lp W=150e-9 L=60e-9 MR=1
MPM4 net23 net17 VDD VNW pm1p2_svt_lp W=300e-9 L=60e-9 MR=1
MPM3 net17 ckn net34 VNW pm1p2_svt_lp W=300e-9 L=60e-9 MR=1
MPM2 net34 D VDD VNW pm1p2_svt_lp W=300e-9 L=60e-9 MR=1
MPM1 ckb ckn VDD VNW pm1p2_svt_lp W=300e-9 L=60e-9 MR=1
MPM0 ckn CK VDD VNW pm1p2_svt_lp W=300e-9 L=60e-9 MR=1
.ENDS
.SUBCKT LATQX1_9TSVT CK D Q VDD VSS VNW VPW
MNM8 Q net26 VSS VPW nm1p2_svt_lp W=470e-9 L=60e-9 MR=1
MNM7 net26 net23 VSS VPW nm1p2_svt_lp W=470e-9 L=60e-9 MR=1
MNM5 net31 net23 VSS VPW nm1p2_svt_lp W=150e-9 L=60e-9 MR=1
MNM6 net17 ckn net31 VPW nm1p2_svt_lp W=150e-9 L=60e-9 MR=1
MNM4 net23 net17 VSS VPW nm1p2_svt_lp W=470e-9 L=60e-9 MR=1
MNM2 net33 D VSS VPW nm1p2_svt_lp W=230n L=60n MR=1
MNM3 net17 ckb net33 VPW nm1p2_svt_lp W=230n L=60n MR=1
MNM1 ckb ckn VSS VPW nm1p2_svt_lp W=230e-9 L=60e-9 MR=1
MNM0 ckn CK VSS VPW nm1p2_svt_lp W=230e-9 L=60e-9 MR=1
MPM8 Q net26 VDD VNW pm1p2_svt_lp W=590e-9 L=60e-9 MR=1
MPM7 net26 net23 VDD VNW pm1p2_svt_lp W=590e-9 L=60e-9 MR=1
MPM6 net17 ckb net32 VNW pm1p2_svt_lp W=150e-9 L=60e-9 MR=1
MPM5 net32 net23 VDD VNW pm1p2_svt_lp W=150e-9 L=60e-9 MR=1
MPM4 net23 net17 VDD VNW pm1p2_svt_lp W=590e-9 L=60e-9 MR=1
MPM3 net17 ckn net34 VNW pm1p2_svt_lp W=300n L=60n MR=1
MPM2 net34 D VDD VNW pm1p2_svt_lp W=300n L=60n MR=1
MPM1 ckb ckn VDD VNW pm1p2_svt_lp W=300e-9 L=60e-9 MR=1
MPM0 ckn CK VDD VNW pm1p2_svt_lp W=300e-9 L=60e-9 MR=1
.ENDS
.SUBCKT LATQX2_9TSVT CK D Q VDD VSS VNW VPW
MNM8 Q net26 VSS VPW nm1p2_svt_lp W=940e-9 L=60e-9 MR=1
MNM7 net26 net23 VSS VPW nm1p2_svt_lp W=470e-9 L=60e-9 MR=1
MNM5 net31 net23 VSS VPW nm1p2_svt_lp W=150e-9 L=60e-9 MR=1
MNM6 net17 ckn net31 VPW nm1p2_svt_lp W=150e-9 L=60e-9 MR=1
MNM4 net23 net17 VSS VPW nm1p2_svt_lp W=470e-9 L=60e-9 MR=1
MNM2 net33 D VSS VPW nm1p2_svt_lp W=470e-9 L=60e-9 MR=1
MNM3 net17 ckb net33 VPW nm1p2_svt_lp W=470e-9 L=60e-9 MR=1
MNM1 ckb ckn VSS VPW nm1p2_svt_lp W=230e-9 L=60e-9 MR=1
MNM0 ckn CK VSS VPW nm1p2_svt_lp W=230e-9 L=60e-9 MR=1
MPM8 Q net26 VDD VNW pm1p2_svt_lp W=1.18e-6 L=60e-9 MR=1
MPM7 net26 net23 VDD VNW pm1p2_svt_lp W=590e-9 L=60e-9 MR=1
MPM6 net17 ckb net32 VNW pm1p2_svt_lp W=150e-9 L=60e-9 MR=1
MPM5 net32 net23 VDD VNW pm1p2_svt_lp W=150e-9 L=60e-9 MR=1
MPM4 net23 net17 VDD VNW pm1p2_svt_lp W=590e-9 L=60e-9 MR=1
MPM3 net17 ckn net34 VNW pm1p2_svt_lp W=590e-9 L=60e-9 MR=1
MPM2 net34 D VDD VNW pm1p2_svt_lp W=590e-9 L=60e-9 MR=1
MPM1 ckb ckn VDD VNW pm1p2_svt_lp W=300e-9 L=60e-9 MR=1
MPM0 ckn CK VDD VNW pm1p2_svt_lp W=300e-9 L=60e-9 MR=1
.ENDS
.SUBCKT LATQX4_9TSVT CK D Q VDD VSS VNW VPW
MNM8 Q net26 VSS VPW nm1p2_svt_lp W=1.88e-6 L=60e-9 MR=1
MNM7 net26 net23 VSS VPW nm1p2_svt_lp W=940e-9 L=60e-9 MR=1
MNM5 net31 net23 VSS VPW nm1p2_svt_lp W=150e-9 L=60e-9 MR=1
MNM6 net17 ckn net31 VPW nm1p2_svt_lp W=150e-9 L=60e-9 MR=1
MNM4 net23 net17 VSS VPW nm1p2_svt_lp W=470e-9 L=60e-9 MR=1
MNM2 net33 D VSS VPW nm1p2_svt_lp W=470e-9 L=60e-9 MR=1
MNM3 net17 ckb net33 VPW nm1p2_svt_lp W=470e-9 L=60e-9 MR=1
MNM1 ckb ckn VSS VPW nm1p2_svt_lp W=230n L=60n MR=1
MNM0 ckn CK VSS VPW nm1p2_svt_lp W=230n L=60n MR=1
MPM8 Q net26 VDD VNW pm1p2_svt_lp W=2.36e-6 L=60e-9 MR=1
MPM7 net26 net23 VDD VNW pm1p2_svt_lp W=1.18e-6 L=60e-9 MR=1
MPM6 net17 ckb net32 VNW pm1p2_svt_lp W=150e-9 L=60e-9 MR=1
MPM5 net32 net23 VDD VNW pm1p2_svt_lp W=150e-9 L=60e-9 MR=1
MPM4 net23 net17 VDD VNW pm1p2_svt_lp W=590e-9 L=60e-9 MR=1
MPM3 net17 ckn net34 VNW pm1p2_svt_lp W=590e-9 L=60e-9 MR=1
MPM2 net34 D VDD VNW pm1p2_svt_lp W=590e-9 L=60e-9 MR=1
MPM1 ckb ckn VDD VNW pm1p2_svt_lp W=300n L=60n MR=1
MPM0 ckn CK VDD VNW pm1p2_svt_lp W=300n L=60n MR=1
.ENDS
.SUBCKT LATRNQX0P5_9TSVT CK D Q RN VDD VSS VNW VPW
MNM8 Q net27 VSS VPW nm1p2_svt_lp W=230e-9 L=60e-9 MR=1
MNM7 net27 net24 VSS VPW nm1p2_svt_lp W=230e-9 L=60e-9 MR=1
MNM_RN net32 RN VSS VPW nm1p2_svt_lp W=150e-9 L=60e-9 MR=1
MNM5 net33 net24 net32 VPW nm1p2_svt_lp W=150e-9 L=60e-9 MR=1
MNM6 net15 ckn net33 VPW nm1p2_svt_lp W=150e-9 L=60e-9 MR=1
MNM4 net24 net15 VSS VPW nm1p2_svt_lp W=230e-9 L=60e-9 MR=1
MNM0_RN net35 RN VSS VPW nm1p2_svt_lp W=230e-9 L=60e-9 MR=1
MNM2 net36 D net35 VPW nm1p2_svt_lp W=230e-9 L=60e-9 MR=1
MNM3 net15 ckb net36 VPW nm1p2_svt_lp W=230e-9 L=60e-9 MR=1
MNM1 ckb ckn VSS VPW nm1p2_svt_lp W=230e-9 L=60e-9 MR=1
MNM0 ckn CK VSS VPW nm1p2_svt_lp W=230e-9 L=60e-9 MR=1
MPM8 Q net27 VDD VNW pm1p2_svt_lp W=300e-9 L=60e-9 MR=1
MPM7 net27 net24 VDD VNW pm1p2_svt_lp W=300e-9 L=60e-9 MR=1
MPM6 net15 ckb net34 VNW pm1p2_svt_lp W=150e-9 L=60e-9 MR=1
MPM5 net34 net24 VDD VNW pm1p2_svt_lp W=150e-9 L=60e-9 MR=1
MPM4 net24 net15 VDD VNW pm1p2_svt_lp W=300e-9 L=60e-9 MR=1
MPM3 net15 ckn net37 VNW pm1p2_svt_lp W=300e-9 L=60e-9 MR=1
MPM0_RN net15 RN VDD VNW pm1p2_svt_lp W=300e-9 L=60e-9 MR=1
MPM2 net37 D VDD VNW pm1p2_svt_lp W=300e-9 L=60e-9 MR=1
MPM1 ckb ckn VDD VNW pm1p2_svt_lp W=300e-9 L=60e-9 MR=1
MPM0 ckn CK VDD VNW pm1p2_svt_lp W=300e-9 L=60e-9 MR=1
.ENDS
.SUBCKT LATRNQX1_9TSVT CK D Q RN VDD VSS VNW VPW
MNM8 Q net27 VSS VPW nm1p2_svt_lp W=470e-9 L=60e-9 MR=1
MNM7 net27 net24 VSS VPW nm1p2_svt_lp W=470e-9 L=60e-9 MR=1
MNM_RN net32 RN VSS VPW nm1p2_svt_lp W=150e-9 L=60e-9 MR=1
MNM5 net33 net24 net32 VPW nm1p2_svt_lp W=150e-9 L=60e-9 MR=1
MNM6 net15 ckn net33 VPW nm1p2_svt_lp W=150e-9 L=60e-9 MR=1
MNM4 net24 net15 VSS VPW nm1p2_svt_lp W=470e-9 L=60e-9 MR=1
MNM0_RN net35 RN VSS VPW nm1p2_svt_lp W=230n L=60n MR=1
MNM2 net36 D net35 VPW nm1p2_svt_lp W=230n L=60n MR=1
MNM3 net15 ckb net36 VPW nm1p2_svt_lp W=230n L=60n MR=1
MNM1 ckb ckn VSS VPW nm1p2_svt_lp W=230e-9 L=60e-9 MR=1
MNM0 ckn CK VSS VPW nm1p2_svt_lp W=230e-9 L=60e-9 MR=1
MPM8 Q net27 VDD VNW pm1p2_svt_lp W=590e-9 L=60e-9 MR=1
MPM7 net27 net24 VDD VNW pm1p2_svt_lp W=590e-9 L=60e-9 MR=1
MPM6 net15 ckb net34 VNW pm1p2_svt_lp W=150e-9 L=60e-9 MR=1
MPM5 net34 net24 VDD VNW pm1p2_svt_lp W=150e-9 L=60e-9 MR=1
MPM4 net24 net15 VDD VNW pm1p2_svt_lp W=590e-9 L=60e-9 MR=1
MPM3 net15 ckn net37 VNW pm1p2_svt_lp W=300n L=60n MR=1
MPM0_RN net15 RN VDD VNW pm1p2_svt_lp W=300n L=60n MR=1
MPM2 net37 D VDD VNW pm1p2_svt_lp W=300n L=60n MR=1
MPM1 ckb ckn VDD VNW pm1p2_svt_lp W=300e-9 L=60e-9 MR=1
MPM0 ckn CK VDD VNW pm1p2_svt_lp W=300e-9 L=60e-9 MR=1
.ENDS
.SUBCKT LATRNQX2_9TSVT CK D Q RN VDD VSS VNW VPW
MNM8 Q net27 VSS VPW nm1p2_svt_lp W=940e-9 L=60e-9 MR=1
MNM7 net27 net24 VSS VPW nm1p2_svt_lp W=470e-9 L=60e-9 MR=1
MNM_RN net32 RN VSS VPW nm1p2_svt_lp W=150e-9 L=60e-9 MR=1
MNM5 net33 net24 net32 VPW nm1p2_svt_lp W=150e-9 L=60e-9 MR=1
MNM6 net15 ckn net33 VPW nm1p2_svt_lp W=150e-9 L=60e-9 MR=1
MNM4 net24 net15 VSS VPW nm1p2_svt_lp W=470e-9 L=60e-9 MR=1
MNM0_RN net35 RN VSS VPW nm1p2_svt_lp W=470e-9 L=60e-9 MR=1
MNM2 net36 D net35 VPW nm1p2_svt_lp W=470e-9 L=60e-9 MR=1
MNM3 net15 ckb net36 VPW nm1p2_svt_lp W=470e-9 L=60e-9 MR=1
MNM1 ckb ckn VSS VPW nm1p2_svt_lp W=230e-9 L=60e-9 MR=1
MNM0 ckn CK VSS VPW nm1p2_svt_lp W=230e-9 L=60e-9 MR=1
MPM8 Q net27 VDD VNW pm1p2_svt_lp W=1.18e-6 L=60e-9 MR=1
MPM7 net27 net24 VDD VNW pm1p2_svt_lp W=590e-9 L=60e-9 MR=1
MPM6 net15 ckb net34 VNW pm1p2_svt_lp W=150e-9 L=60e-9 MR=1
MPM5 net34 net24 VDD VNW pm1p2_svt_lp W=150e-9 L=60e-9 MR=1
MPM4 net24 net15 VDD VNW pm1p2_svt_lp W=590e-9 L=60e-9 MR=1
MPM3 net15 ckn net37 VNW pm1p2_svt_lp W=590e-9 L=60e-9 MR=1
MPM0_RN net15 RN VDD VNW pm1p2_svt_lp W=590e-9 L=60e-9 MR=1
MPM2 net37 D VDD VNW pm1p2_svt_lp W=590e-9 L=60e-9 MR=1
MPM1 ckb ckn VDD VNW pm1p2_svt_lp W=300e-9 L=60e-9 MR=1
MPM0 ckn CK VDD VNW pm1p2_svt_lp W=300e-9 L=60e-9 MR=1
.ENDS
.SUBCKT LATRNQX4_9TSVT CK D Q RN VDD VSS VNW VPW
MNM8 Q net27 VSS VPW nm1p2_svt_lp W=1.88e-6 L=60e-9 MR=1
MNM7 net27 net24 VSS VPW nm1p2_svt_lp W=940e-9 L=60e-9 MR=1
MNM_RN net32 RN VSS VPW nm1p2_svt_lp W=150e-9 L=60e-9 MR=1
MNM5 net33 net24 net32 VPW nm1p2_svt_lp W=150e-9 L=60e-9 MR=1
MNM6 net15 ckn net33 VPW nm1p2_svt_lp W=150e-9 L=60e-9 MR=1
MNM4 net24 net15 VSS VPW nm1p2_svt_lp W=470e-9 L=60e-9 MR=1
MNM0_RN net35 RN VSS VPW nm1p2_svt_lp W=470e-9 L=60e-9 MR=1
MNM2 net36 D net35 VPW nm1p2_svt_lp W=470e-9 L=60e-9 MR=1
MNM3 net15 ckb net36 VPW nm1p2_svt_lp W=470e-9 L=60e-9 MR=1
MNM1 ckb ckn VSS VPW nm1p2_svt_lp W=230n L=60n MR=1
MNM0 ckn CK VSS VPW nm1p2_svt_lp W=230n L=60n MR=1
MPM8 Q net27 VDD VNW pm1p2_svt_lp W=2.36e-6 L=60e-9 MR=1
MPM7 net27 net24 VDD VNW pm1p2_svt_lp W=1.18e-6 L=60e-9 MR=1
MPM6 net15 ckb net34 VNW pm1p2_svt_lp W=150e-9 L=60e-9 MR=1
MPM5 net34 net24 VDD VNW pm1p2_svt_lp W=150e-9 L=60e-9 MR=1
MPM4 net24 net15 VDD VNW pm1p2_svt_lp W=590e-9 L=60e-9 MR=1
MPM3 net15 ckn net37 VNW pm1p2_svt_lp W=590e-9 L=60e-9 MR=1
MPM0_RN net15 RN VDD VNW pm1p2_svt_lp W=590e-9 L=60e-9 MR=1
MPM2 net37 D VDD VNW pm1p2_svt_lp W=590e-9 L=60e-9 MR=1
MPM1 ckb ckn VDD VNW pm1p2_svt_lp W=300n L=60n MR=1
MPM0 ckn CK VDD VNW pm1p2_svt_lp W=300n L=60n MR=1
.ENDS
.SUBCKT LATRSNQX0P5_9TSVT CK D Q RN SN VDD VSS VNW VPW
MNM8 Q net28 VSS VPW nm1p2_svt_lp W=230e-9 L=60e-9 MR=1
MNM7 net28 net23 VSS VPW nm1p2_svt_lp W=230e-9 L=60e-9 MR=1
MNM_RN net35 RN VSS VPW nm1p2_svt_lp W=150e-9 L=60e-9 MR=1
MNM5 net36 net23 net35 VPW nm1p2_svt_lp W=150e-9 L=60e-9 MR=1
MNM6 net17 ckn net36 VPW nm1p2_svt_lp W=150e-9 L=60e-9 MR=1
MNM4 net38 net17 VSS VPW nm1p2_svt_lp W=230e-9 L=60e-9 MR=1
MNM_SN net23 SN net38 VPW nm1p2_svt_lp W=230e-9 L=60e-9 MR=1
MNM0_RN net39 RN VSS VPW nm1p2_svt_lp W=230e-9 L=60e-9 MR=1
MNM2 net40 D net39 VPW nm1p2_svt_lp W=230e-9 L=60e-9 MR=1
MNM3 net17 ckb net40 VPW nm1p2_svt_lp W=230e-9 L=60e-9 MR=1
MNM1 ckb ckn VSS VPW nm1p2_svt_lp W=230e-9 L=60e-9 MR=1
MNM0 ckn CK VSS VPW nm1p2_svt_lp W=230e-9 L=60e-9 MR=1
MPM8 Q net28 VDD VNW pm1p2_svt_lp W=300e-9 L=60e-9 MR=1
MPM7 net28 net23 VDD VNW pm1p2_svt_lp W=300e-9 L=60e-9 MR=1
MPM6 net17 ckb net37 VNW pm1p2_svt_lp W=150e-9 L=60e-9 MR=1
MPM5 net37 net23 VDD VNW pm1p2_svt_lp W=150e-9 L=60e-9 MR=1
MPM_SN net23 SN VDD VNW pm1p2_svt_lp W=300e-9 L=60e-9 MR=1
MPM4 net23 net17 VDD VNW pm1p2_svt_lp W=300e-9 L=60e-9 MR=1
MPM3 net17 ckn net41 VNW pm1p2_svt_lp W=300e-9 L=60e-9 MR=1
MPM0_RN net17 RN VDD VNW pm1p2_svt_lp W=300e-9 L=60e-9 MR=1
MPM2 net41 D VDD VNW pm1p2_svt_lp W=300e-9 L=60e-9 MR=1
MPM1 ckb ckn VDD VNW pm1p2_svt_lp W=300e-9 L=60e-9 MR=1
MPM0 ckn CK VDD VNW pm1p2_svt_lp W=300e-9 L=60e-9 MR=1
.ENDS
.SUBCKT LATRSNQX1_9TSVT CK D Q RN SN VDD VSS VNW VPW
MNM8 Q net28 VSS VPW nm1p2_svt_lp W=470e-9 L=60e-9 MR=1
MNM7 net28 net23 VSS VPW nm1p2_svt_lp W=470e-9 L=60e-9 MR=1
MNM_RN net35 RN VSS VPW nm1p2_svt_lp W=150e-9 L=60e-9 MR=1
MNM5 net36 net23 net35 VPW nm1p2_svt_lp W=150e-9 L=60e-9 MR=1
MNM6 net17 ckn net36 VPW nm1p2_svt_lp W=150e-9 L=60e-9 MR=1
MNM4 net38 net17 VSS VPW nm1p2_svt_lp W=470e-9 L=60e-9 MR=1
MNM_SN net23 SN net38 VPW nm1p2_svt_lp W=470e-9 L=60e-9 MR=1
MNM0_RN net39 RN VSS VPW nm1p2_svt_lp W=230n L=60n MR=1
MNM2 net40 D net39 VPW nm1p2_svt_lp W=230n L=60n MR=1
MNM3 net17 ckb net40 VPW nm1p2_svt_lp W=230n L=60n MR=1
MNM1 ckb ckn VSS VPW nm1p2_svt_lp W=230e-9 L=60e-9 MR=1
MNM0 ckn CK VSS VPW nm1p2_svt_lp W=230e-9 L=60e-9 MR=1
MPM8 Q net28 VDD VNW pm1p2_svt_lp W=590e-9 L=60e-9 MR=1
MPM7 net28 net23 VDD VNW pm1p2_svt_lp W=590e-9 L=60e-9 MR=1
MPM6 net17 ckb net37 VNW pm1p2_svt_lp W=150e-9 L=60e-9 MR=1
MPM5 net37 net23 VDD VNW pm1p2_svt_lp W=150e-9 L=60e-9 MR=1
MPM_SN net23 SN VDD VNW pm1p2_svt_lp W=590e-9 L=60e-9 MR=1
MPM4 net23 net17 VDD VNW pm1p2_svt_lp W=590e-9 L=60e-9 MR=1
MPM3 net17 ckn net41 VNW pm1p2_svt_lp W=300n L=60n MR=1
MPM0_RN net17 RN VDD VNW pm1p2_svt_lp W=300n L=60n MR=1
MPM2 net41 D VDD VNW pm1p2_svt_lp W=300n L=60n MR=1
MPM1 ckb ckn VDD VNW pm1p2_svt_lp W=300e-9 L=60e-9 MR=1
MPM0 ckn CK VDD VNW pm1p2_svt_lp W=300e-9 L=60e-9 MR=1
.ENDS
.SUBCKT LATRSNQX2_9TSVT CK D Q RN SN VDD VSS VNW VPW
MNM8 Q net28 VSS VPW nm1p2_svt_lp W=940e-9 L=60e-9 MR=1
MNM7 net28 net23 VSS VPW nm1p2_svt_lp W=470e-9 L=60e-9 MR=1
MNM_RN net35 RN VSS VPW nm1p2_svt_lp W=150e-9 L=60e-9 MR=1
MNM5 net36 net23 net35 VPW nm1p2_svt_lp W=150e-9 L=60e-9 MR=1
MNM6 net17 ckn net36 VPW nm1p2_svt_lp W=150e-9 L=60e-9 MR=1
MNM4 net38 net17 VSS VPW nm1p2_svt_lp W=470e-9 L=60e-9 MR=1
MNM_SN net23 SN net38 VPW nm1p2_svt_lp W=470e-9 L=60e-9 MR=1
MNM0_RN net39 RN VSS VPW nm1p2_svt_lp W=470e-9 L=60e-9 MR=1
MNM2 net40 D net39 VPW nm1p2_svt_lp W=470e-9 L=60e-9 MR=1
MNM3 net17 ckb net40 VPW nm1p2_svt_lp W=470e-9 L=60e-9 MR=1
MNM1 ckb ckn VSS VPW nm1p2_svt_lp W=230e-9 L=60e-9 MR=1
MNM0 ckn CK VSS VPW nm1p2_svt_lp W=230e-9 L=60e-9 MR=1
MPM8 Q net28 VDD VNW pm1p2_svt_lp W=1.18e-6 L=60e-9 MR=1
MPM7 net28 net23 VDD VNW pm1p2_svt_lp W=590e-9 L=60e-9 MR=1
MPM6 net17 ckb net37 VNW pm1p2_svt_lp W=150e-9 L=60e-9 MR=1
MPM5 net37 net23 VDD VNW pm1p2_svt_lp W=150e-9 L=60e-9 MR=1
MPM_SN net23 SN VDD VNW pm1p2_svt_lp W=590e-9 L=60e-9 MR=1
MPM4 net23 net17 VDD VNW pm1p2_svt_lp W=590e-9 L=60e-9 MR=1
MPM3 net17 ckn net41 VNW pm1p2_svt_lp W=590e-9 L=60e-9 MR=1
MPM0_RN net17 RN VDD VNW pm1p2_svt_lp W=590e-9 L=60e-9 MR=1
MPM2 net41 D VDD VNW pm1p2_svt_lp W=590e-9 L=60e-9 MR=1
MPM1 ckb ckn VDD VNW pm1p2_svt_lp W=300e-9 L=60e-9 MR=1
MPM0 ckn CK VDD VNW pm1p2_svt_lp W=300e-9 L=60e-9 MR=1
.ENDS
.SUBCKT LATRSNQX4_9TSVT CK D Q RN SN VDD VSS VNW VPW
MNM8 Q net28 VSS VPW nm1p2_svt_lp W=1.88e-6 L=60e-9 MR=1
MNM7 net28 net23 VSS VPW nm1p2_svt_lp W=940e-9 L=60e-9 MR=1
MNM_RN net35 RN VSS VPW nm1p2_svt_lp W=150e-9 L=60e-9 MR=1
MNM5 net36 net23 net35 VPW nm1p2_svt_lp W=150e-9 L=60e-9 MR=1
MNM6 net17 ckn net36 VPW nm1p2_svt_lp W=150e-9 L=60e-9 MR=1
MNM4 net38 net17 VSS VPW nm1p2_svt_lp W=470e-9 L=60e-9 MR=1
MNM_SN net23 SN net38 VPW nm1p2_svt_lp W=470e-9 L=60e-9 MR=1
MNM0_RN net39 RN VSS VPW nm1p2_svt_lp W=470e-9 L=60e-9 MR=1
MNM2 net40 D net39 VPW nm1p2_svt_lp W=470e-9 L=60e-9 MR=1
MNM3 net17 ckb net40 VPW nm1p2_svt_lp W=470e-9 L=60e-9 MR=1
MNM1 ckb ckn VSS VPW nm1p2_svt_lp W=230n L=60n MR=1
MNM0 ckn CK VSS VPW nm1p2_svt_lp W=230n L=60n MR=1
MPM8 Q net28 VDD VNW pm1p2_svt_lp W=2.36e-6 L=60e-9 MR=1
MPM7 net28 net23 VDD VNW pm1p2_svt_lp W=1.18e-6 L=60e-9 MR=1
MPM6 net17 ckb net37 VNW pm1p2_svt_lp W=150e-9 L=60e-9 MR=1
MPM5 net37 net23 VDD VNW pm1p2_svt_lp W=150e-9 L=60e-9 MR=1
MPM_SN net23 SN VDD VNW pm1p2_svt_lp W=590e-9 L=60e-9 MR=1
MPM4 net23 net17 VDD VNW pm1p2_svt_lp W=590e-9 L=60e-9 MR=1
MPM3 net17 ckn net41 VNW pm1p2_svt_lp W=590e-9 L=60e-9 MR=1
MPM0_RN net17 RN VDD VNW pm1p2_svt_lp W=590e-9 L=60e-9 MR=1
MPM2 net41 D VDD VNW pm1p2_svt_lp W=590e-9 L=60e-9 MR=1
MPM1 ckb ckn VDD VNW pm1p2_svt_lp W=300n L=60n MR=1
MPM0 ckn CK VDD VNW pm1p2_svt_lp W=300n L=60n MR=1
.ENDS
.SUBCKT LATSNQX0P5_9TSVT CK D Q SN VDD VSS VNW VPW
MNM8 Q net27 VSS VPW nm1p2_svt_lp W=230e-9 L=60e-9 MR=1
MNM7 net27 net22 VSS VPW nm1p2_svt_lp W=230e-9 L=60e-9 MR=1
MNM5 net34 net22 VSS VPW nm1p2_svt_lp W=150e-9 L=60e-9 MR=1
MNM6 net19 ckn net34 VPW nm1p2_svt_lp W=150e-9 L=60e-9 MR=1
MNM4 net36 net19 VSS VPW nm1p2_svt_lp W=230e-9 L=60e-9 MR=1
MNM_SN net22 SN net36 VPW nm1p2_svt_lp W=230e-9 L=60e-9 MR=1
MNM2 net37 D VSS VPW nm1p2_svt_lp W=230e-9 L=60e-9 MR=1
MNM3 net19 ckb net37 VPW nm1p2_svt_lp W=230e-9 L=60e-9 MR=1
MNM1 ckb ckn VSS VPW nm1p2_svt_lp W=230e-9 L=60e-9 MR=1
MNM0 ckn CK VSS VPW nm1p2_svt_lp W=230e-9 L=60e-9 MR=1
MPM8 Q net27 VDD VNW pm1p2_svt_lp W=300e-9 L=60e-9 MR=1
MPM7 net27 net22 VDD VNW pm1p2_svt_lp W=300e-9 L=60e-9 MR=1
MPM6 net19 ckb net35 VNW pm1p2_svt_lp W=150e-9 L=60e-9 MR=1
MPM5 net35 net22 VDD VNW pm1p2_svt_lp W=150e-9 L=60e-9 MR=1
MPM_SN net22 SN VDD VNW pm1p2_svt_lp W=300e-9 L=60e-9 MR=1
MPM4 net22 net19 VDD VNW pm1p2_svt_lp W=300e-9 L=60e-9 MR=1
MPM3 net19 ckn net38 VNW pm1p2_svt_lp W=300e-9 L=60e-9 MR=1
MPM2 net38 D VDD VNW pm1p2_svt_lp W=300e-9 L=60e-9 MR=1
MPM1 ckb ckn VDD VNW pm1p2_svt_lp W=300e-9 L=60e-9 MR=1
MPM0 ckn CK VDD VNW pm1p2_svt_lp W=300e-9 L=60e-9 MR=1
.ENDS
.SUBCKT LATSNQX1_9TSVT CK D Q SN VDD VSS VNW VPW
MNM8 Q net27 VSS VPW nm1p2_svt_lp W=470e-9 L=60e-9 MR=1
MNM7 net27 net22 VSS VPW nm1p2_svt_lp W=470e-9 L=60e-9 MR=1
MNM5 net34 net22 VSS VPW nm1p2_svt_lp W=150e-9 L=60e-9 MR=1
MNM6 net19 ckn net34 VPW nm1p2_svt_lp W=150e-9 L=60e-9 MR=1
MNM4 net36 net19 VSS VPW nm1p2_svt_lp W=470e-9 L=60e-9 MR=1
MNM_SN net22 SN net36 VPW nm1p2_svt_lp W=470e-9 L=60e-9 MR=1
MNM2 net37 D VSS VPW nm1p2_svt_lp W=230n L=60n MR=1
MNM3 net19 ckb net37 VPW nm1p2_svt_lp W=230n L=60n MR=1
MNM1 ckb ckn VSS VPW nm1p2_svt_lp W=230e-9 L=60e-9 MR=1
MNM0 ckn CK VSS VPW nm1p2_svt_lp W=230e-9 L=60e-9 MR=1
MPM8 Q net27 VDD VNW pm1p2_svt_lp W=590e-9 L=60e-9 MR=1
MPM7 net27 net22 VDD VNW pm1p2_svt_lp W=590e-9 L=60e-9 MR=1
MPM6 net19 ckb net35 VNW pm1p2_svt_lp W=150e-9 L=60e-9 MR=1
MPM5 net35 net22 VDD VNW pm1p2_svt_lp W=150e-9 L=60e-9 MR=1
MPM_SN net22 SN VDD VNW pm1p2_svt_lp W=590e-9 L=60e-9 MR=1
MPM4 net22 net19 VDD VNW pm1p2_svt_lp W=590e-9 L=60e-9 MR=1
MPM3 net19 ckn net38 VNW pm1p2_svt_lp W=300n L=60n MR=1
MPM2 net38 D VDD VNW pm1p2_svt_lp W=300n L=60n MR=1
MPM1 ckb ckn VDD VNW pm1p2_svt_lp W=300e-9 L=60e-9 MR=1
MPM0 ckn CK VDD VNW pm1p2_svt_lp W=300e-9 L=60e-9 MR=1
.ENDS
.SUBCKT LATSNQX2_9TSVT CK D Q SN VDD VSS VNW VPW
MNM8 Q net27 VSS VPW nm1p2_svt_lp W=940e-9 L=60e-9 MR=1
MNM7 net27 net22 VSS VPW nm1p2_svt_lp W=470e-9 L=60e-9 MR=1
MNM5 net34 net22 VSS VPW nm1p2_svt_lp W=150e-9 L=60e-9 MR=1
MNM6 net19 ckn net34 VPW nm1p2_svt_lp W=150e-9 L=60e-9 MR=1
MNM4 net36 net19 VSS VPW nm1p2_svt_lp W=470e-9 L=60e-9 MR=1
MNM_SN net22 SN net36 VPW nm1p2_svt_lp W=470e-9 L=60e-9 MR=1
MNM2 net37 D VSS VPW nm1p2_svt_lp W=470e-9 L=60e-9 MR=1
MNM3 net19 ckb net37 VPW nm1p2_svt_lp W=470e-9 L=60e-9 MR=1
MNM1 ckb ckn VSS VPW nm1p2_svt_lp W=230e-9 L=60e-9 MR=1
MNM0 ckn CK VSS VPW nm1p2_svt_lp W=230e-9 L=60e-9 MR=1
MPM8 Q net27 VDD VNW pm1p2_svt_lp W=1.18e-6 L=60e-9 MR=1
MPM7 net27 net22 VDD VNW pm1p2_svt_lp W=590e-9 L=60e-9 MR=1
MPM6 net19 ckb net35 VNW pm1p2_svt_lp W=150e-9 L=60e-9 MR=1
MPM5 net35 net22 VDD VNW pm1p2_svt_lp W=150e-9 L=60e-9 MR=1
MPM_SN net22 SN VDD VNW pm1p2_svt_lp W=590e-9 L=60e-9 MR=1
MPM4 net22 net19 VDD VNW pm1p2_svt_lp W=590e-9 L=60e-9 MR=1
MPM3 net19 ckn net38 VNW pm1p2_svt_lp W=590e-9 L=60e-9 MR=1
MPM2 net38 D VDD VNW pm1p2_svt_lp W=590e-9 L=60e-9 MR=1
MPM1 ckb ckn VDD VNW pm1p2_svt_lp W=300e-9 L=60e-9 MR=1
MPM0 ckn CK VDD VNW pm1p2_svt_lp W=300e-9 L=60e-9 MR=1
.ENDS
.SUBCKT LATSNQX4_9TSVT CK D Q SN VDD VSS VNW VPW
MNM8 Q net27 VSS VPW nm1p2_svt_lp W=1.88e-6 L=60e-9 MR=1
MNM7 net27 net22 VSS VPW nm1p2_svt_lp W=940e-9 L=60e-9 MR=1
MNM5 net34 net22 VSS VPW nm1p2_svt_lp W=150e-9 L=60e-9 MR=1
MNM6 net19 ckn net34 VPW nm1p2_svt_lp W=150e-9 L=60e-9 MR=1
MNM4 net36 net19 VSS VPW nm1p2_svt_lp W=470e-9 L=60e-9 MR=1
MNM_SN net22 SN net36 VPW nm1p2_svt_lp W=470e-9 L=60e-9 MR=1
MNM2 net37 D VSS VPW nm1p2_svt_lp W=470e-9 L=60e-9 MR=1
MNM3 net19 ckb net37 VPW nm1p2_svt_lp W=470e-9 L=60e-9 MR=1
MNM1 ckb ckn VSS VPW nm1p2_svt_lp W=230n L=60n MR=1
MNM0 ckn CK VSS VPW nm1p2_svt_lp W=230n L=60n MR=1
MPM8 Q net27 VDD VNW pm1p2_svt_lp W=2.36e-6 L=60e-9 MR=1
MPM7 net27 net22 VDD VNW pm1p2_svt_lp W=1.18e-6 L=60e-9 MR=1
MPM6 net19 ckb net35 VNW pm1p2_svt_lp W=150e-9 L=60e-9 MR=1
MPM5 net35 net22 VDD VNW pm1p2_svt_lp W=150e-9 L=60e-9 MR=1
MPM_SN net22 SN VDD VNW pm1p2_svt_lp W=590e-9 L=60e-9 MR=1
MPM4 net22 net19 VDD VNW pm1p2_svt_lp W=590e-9 L=60e-9 MR=1
MPM3 net19 ckn net38 VNW pm1p2_svt_lp W=590e-9 L=60e-9 MR=1
MPM2 net38 D VDD VNW pm1p2_svt_lp W=590e-9 L=60e-9 MR=1
MPM1 ckb ckn VDD VNW pm1p2_svt_lp W=300n L=60n MR=1
MPM0 ckn CK VDD VNW pm1p2_svt_lp W=300n L=60n MR=1
.ENDS
.SUBCKT MAOI222X0P5_9TSVT A B C VDD VSS Y VNW VPW
MNM4 Y A net17 VPW nm1p2_svt_lp W=230e-9 L=60e-9 MR=1
MNM3 net17 C VSS VPW nm1p2_svt_lp W=230e-9 L=60e-9 MR=1
MNM2 Y B net17 VPW nm1p2_svt_lp W=230e-9 L=60e-9 MR=1
MNM1 net29 B VSS VPW nm1p2_svt_lp W=230e-9 L=60e-9 MR=1
MNM0 Y A net29 VPW nm1p2_svt_lp W=230e-9 L=60e-9 MR=1
MPM4 Y A net18 VNW pm1p2_svt_lp W=300e-9 L=60e-9 MR=1
MPM3 net18 C VDD VNW pm1p2_svt_lp W=300e-9 L=60e-9 MR=1
MPM2 net28 B VDD VNW pm1p2_svt_lp W=300e-9 L=60e-9 MR=1
MPM1 Y B net18 VNW pm1p2_svt_lp W=300e-9 L=60e-9 MR=1
MPM0 Y A net28 VNW pm1p2_svt_lp W=300e-9 L=60e-9 MR=1
.ENDS
.SUBCKT MAOI222X1_9TSVT A B C VDD VSS Y VNW VPW
MNM4 Y A net17 VPW nm1p2_svt_lp W=470e-9 L=60e-9 MR=1
MNM3 net17 C VSS VPW nm1p2_svt_lp W=470e-9 L=60e-9 MR=1
MNM2 Y B net17 VPW nm1p2_svt_lp W=470e-9 L=60e-9 MR=1
MNM1 net29 B VSS VPW nm1p2_svt_lp W=470e-9 L=60e-9 MR=1
MNM0 Y A net29 VPW nm1p2_svt_lp W=470e-9 L=60e-9 MR=1
MPM4 Y A net18 VNW pm1p2_svt_lp W=590e-9 L=60e-9 MR=1
MPM3 net18 C VDD VNW pm1p2_svt_lp W=590e-9 L=60e-9 MR=1
MPM2 net28 B VDD VNW pm1p2_svt_lp W=590e-9 L=60e-9 MR=1
MPM1 Y B net18 VNW pm1p2_svt_lp W=590e-9 L=60e-9 MR=1
MPM0 Y A net28 VNW pm1p2_svt_lp W=590e-9 L=60e-9 MR=1
.ENDS
.SUBCKT MAOI222X2_9TSVT A B C VDD VSS Y VNW VPW
MNM6 Y net23 VSS VPW nm1p2_svt_lp W=940e-9 L=60e-9 MR=1
MNM5 net23 net16 VSS VPW nm1p2_svt_lp W=470e-9 L=60e-9 MR=1
MNM4 net16 A net17 VPW nm1p2_svt_lp W=230n L=60n MR=1
MNM3 net17 C VSS VPW nm1p2_svt_lp W=230n L=60n MR=1
MNM2 net16 B net17 VPW nm1p2_svt_lp W=230n L=60n MR=1
MNM1 net29 B VSS VPW nm1p2_svt_lp W=230n L=60n MR=1
MNM0 net16 A net29 VPW nm1p2_svt_lp W=230n L=60n MR=1
MPM6 Y net23 VDD VNW pm1p2_svt_lp W=1.18e-6 L=60e-9 MR=1
MPM5 net23 net16 VDD VNW pm1p2_svt_lp W=590e-9 L=60e-9 MR=1
MPM4 net16 A net18 VNW pm1p2_svt_lp W=300n L=60n MR=1
MPM3 net18 C VDD VNW pm1p2_svt_lp W=300n L=60n MR=1
MPM2 net28 B VDD VNW pm1p2_svt_lp W=300n L=60n MR=1
MPM1 net16 B net18 VNW pm1p2_svt_lp W=300n L=60n MR=1
MPM0 net16 A net28 VNW pm1p2_svt_lp W=300n L=60n MR=1
.ENDS
.SUBCKT MAOI222X4_9TSVT A B C VDD VSS Y VNW VPW
MNM6 Y net23 VSS VPW nm1p2_svt_lp W=1.88e-6 L=60e-9 MR=1
MNM5 net23 net16 VSS VPW nm1p2_svt_lp W=940e-9 L=60e-9 MR=1
MNM4 net16 A net17 VPW nm1p2_svt_lp W=470e-9 L=60e-9 MR=1
MNM3 net17 C VSS VPW nm1p2_svt_lp W=470e-9 L=60e-9 MR=1
MNM2 net16 B net17 VPW nm1p2_svt_lp W=470e-9 L=60e-9 MR=1
MNM1 net29 B VSS VPW nm1p2_svt_lp W=470e-9 L=60e-9 MR=1
MNM0 net16 A net29 VPW nm1p2_svt_lp W=470e-9 L=60e-9 MR=1
MPM6 Y net23 VDD VNW pm1p2_svt_lp W=2.36e-6 L=60e-9 MR=1
MPM5 net23 net16 VDD VNW pm1p2_svt_lp W=1.18e-6 L=60e-9 MR=1
MPM4 net16 A net18 VNW pm1p2_svt_lp W=590e-9 L=60e-9 MR=1
MPM3 net18 C VDD VNW pm1p2_svt_lp W=590e-9 L=60e-9 MR=1
MPM2 net28 B VDD VNW pm1p2_svt_lp W=590e-9 L=60e-9 MR=1
MPM1 net16 B net18 VNW pm1p2_svt_lp W=590e-9 L=60e-9 MR=1
MPM0 net16 A net28 VNW pm1p2_svt_lp W=590e-9 L=60e-9 MR=1
.ENDS
.SUBCKT MAOI22X0P5_9TSVT A0 A1 B0 B1 VDD VSS Y VNW VPW
MPM4 net23 net17 VDD VNW pm1p2_svt_lp W=300e-9 L=60e-9 MR=1
MPM3 Y A1 net23 VNW pm1p2_svt_lp W=300e-9 L=60e-9 MR=1
MPM2 Y A0 net23 VNW pm1p2_svt_lp W=300e-9 L=60e-9 MR=1
MPM1 net27 B1 VDD VNW pm1p2_svt_lp W=300e-9 L=60e-9 MR=1
MPM0 net17 B0 net27 VNW pm1p2_svt_lp W=300e-9 L=60e-9 MR=1
MNM4 Y net17 VSS VPW nm1p2_svt_lp W=230e-9 L=60e-9 MR=1
MNM3 net26 A1 VSS VPW nm1p2_svt_lp W=230e-9 L=60e-9 MR=1
MNM2 Y A0 net26 VPW nm1p2_svt_lp W=230e-9 L=60e-9 MR=1
MNM1 net17 B1 VSS VPW nm1p2_svt_lp W=230e-9 L=60e-9 MR=1
MNM0 net17 B0 VSS VPW nm1p2_svt_lp W=230e-9 L=60e-9 MR=1
.ENDS
.SUBCKT MAOI22X1_9TSVT A0 A1 B0 B1 VDD VSS Y VNW VPW
MPM4 net23 net17 VDD VNW pm1p2_svt_lp W=590e-9 L=60e-9 MR=1
MPM3 Y A1 net23 VNW pm1p2_svt_lp W=590e-9 L=60e-9 MR=1
MPM2 Y A0 net23 VNW pm1p2_svt_lp W=590e-9 L=60e-9 MR=1
MPM1 net27 B1 VDD VNW pm1p2_svt_lp W=300n L=60n MR=1
MPM0 net17 B0 net27 VNW pm1p2_svt_lp W=300n L=60n MR=1
MNM4 Y net17 VSS VPW nm1p2_svt_lp W=470e-9 L=60e-9 MR=1
MNM3 net26 A1 VSS VPW nm1p2_svt_lp W=470e-9 L=60e-9 MR=1
MNM2 Y A0 net26 VPW nm1p2_svt_lp W=470e-9 L=60e-9 MR=1
MNM1 net17 B1 VSS VPW nm1p2_svt_lp W=230n L=60n MR=1
MNM0 net17 B0 VSS VPW nm1p2_svt_lp W=230n L=60n MR=1
.ENDS
.SUBCKT MAOI22X2_9TSVT A0 A1 B0 B1 VDD VSS Y VNW VPW
MNM5 Y net27 VSS VPW nm1p2_svt_lp W=940e-9 L=60e-9 MR=1
MNM4 net21 net18 VSS VPW nm1p2_svt_lp W=470e-9 L=60e-9 MR=1
MNM1 net27 B1 net21 VPW nm1p2_svt_lp W=470e-9 L=60e-9 MR=1
MNM0 net27 B0 net21 VPW nm1p2_svt_lp W=470e-9 L=60e-9 MR=1
MNM3 net29 A1 VSS VPW nm1p2_svt_lp W=230n L=60n MR=1
MNM2 net18 A0 net29 VPW nm1p2_svt_lp W=230n L=60n MR=1
MPM5 Y net27 VDD VNW pm1p2_svt_lp W=1.18e-6 L=60e-9 MR=1
MPM4 net27 net18 VDD VNW pm1p2_svt_lp W=590e-9 L=60e-9 MR=1
MPM1 net28 B1 VDD VNW pm1p2_svt_lp W=590e-9 L=60e-9 MR=1
MPM0 net27 B0 net28 VNW pm1p2_svt_lp W=590e-9 L=60e-9 MR=1
MPM3 net18 A1 VDD VNW pm1p2_svt_lp W=300n L=60n MR=1
MPM2 net18 A0 VDD VNW pm1p2_svt_lp W=300n L=60n MR=1
.ENDS
.SUBCKT MAOI22X4_9TSVT A0 A1 B0 B1 VDD VSS Y VNW VPW
MNM5 Y net27 VSS VPW nm1p2_svt_lp W=1.88e-6 L=60e-9 MR=1
MNM4 net21 net18 VSS VPW nm1p2_svt_lp W=940e-9 L=60e-9 MR=1
MNM1 net27 B1 net21 VPW nm1p2_svt_lp W=940e-9 L=60e-9 MR=1
MNM0 net27 B0 net21 VPW nm1p2_svt_lp W=940e-9 L=60e-9 MR=1
MNM3 net29 A1 VSS VPW nm1p2_svt_lp W=470e-9 L=60e-9 MR=1
MNM2 net18 A0 net29 VPW nm1p2_svt_lp W=470e-9 L=60e-9 MR=1
MPM5 Y net27 VDD VNW pm1p2_svt_lp W=2.36e-6 L=60e-9 MR=1
MPM4 net27 net18 VDD VNW pm1p2_svt_lp W=1.18e-6 L=60e-9 MR=1
MPM1 net28 B1 VDD VNW pm1p2_svt_lp W=1.18e-6 L=60e-9 MR=1
MPM0 net27 B0 net28 VNW pm1p2_svt_lp W=1.18e-6 L=60e-9 MR=1
MPM3 net18 A1 VDD VNW pm1p2_svt_lp W=590e-9 L=60e-9 MR=1
MPM2 net18 A0 VDD VNW pm1p2_svt_lp W=590e-9 L=60e-9 MR=1
.ENDS
.SUBCKT MOAI22X0P5_9TSVT A0 A1 B0 B1 VDD VSS Y VNW VPW
MNM4 net21 net18 VSS VPW nm1p2_svt_lp W=230e-9 L=60e-9 MR=1
MNM1 Y A1 net21 VPW nm1p2_svt_lp W=230e-9 L=60e-9 MR=1
MNM0 Y A0 net21 VPW nm1p2_svt_lp W=230e-9 L=60e-9 MR=1
MNM3 net26 B1 VSS VPW nm1p2_svt_lp W=230e-9 L=60e-9 MR=1
MNM2 net18 B0 net26 VPW nm1p2_svt_lp W=230e-9 L=60e-9 MR=1
MPM4 Y net18 VDD VNW pm1p2_svt_lp W=300e-9 L=60e-9 MR=1
MPM1 net25 A1 VDD VNW pm1p2_svt_lp W=300e-9 L=60e-9 MR=1
MPM0 Y A0 net25 VNW pm1p2_svt_lp W=300e-9 L=60e-9 MR=1
MPM3 net18 B1 VDD VNW pm1p2_svt_lp W=300e-9 L=60e-9 MR=1
MPM2 net18 B0 VDD VNW pm1p2_svt_lp W=300e-9 L=60e-9 MR=1
.ENDS
.SUBCKT MOAI22X1_9TSVT A0 A1 B0 B1 VDD VSS Y VNW VPW
MNM4 net21 net18 VSS VPW nm1p2_svt_lp W=470e-9 L=60e-9 MR=1
MNM1 Y A1 net21 VPW nm1p2_svt_lp W=470e-9 L=60e-9 MR=1
MNM0 Y A0 net21 VPW nm1p2_svt_lp W=470e-9 L=60e-9 MR=1
MNM3 net26 B1 VSS VPW nm1p2_svt_lp W=230n L=60n MR=1
MNM2 net18 B0 net26 VPW nm1p2_svt_lp W=230n L=60n MR=1
MPM4 Y net18 VDD VNW pm1p2_svt_lp W=590e-9 L=60e-9 MR=1
MPM1 net25 A1 VDD VNW pm1p2_svt_lp W=590e-9 L=60e-9 MR=1
MPM0 Y A0 net25 VNW pm1p2_svt_lp W=590e-9 L=60e-9 MR=1
MPM3 net18 B1 VDD VNW pm1p2_svt_lp W=300n L=60n MR=1
MPM2 net18 B0 VDD VNW pm1p2_svt_lp W=300n L=60n MR=1
.ENDS
.SUBCKT MOAI22X2_9TSVT A0 A1 B0 B1 VDD VSS Y VNW VPW
MPM5 Y net22 VDD VNW pm1p2_svt_lp W=1.18e-6 L=60e-9 MR=1
MPM4 net23 net17 VDD VNW pm1p2_svt_lp W=590e-9 L=60e-9 MR=1
MPM3 net22 B1 net23 VNW pm1p2_svt_lp W=590e-9 L=60e-9 MR=1
MPM2 net22 B0 net23 VNW pm1p2_svt_lp W=590e-9 L=60e-9 MR=1
MPM1 net30 A1 VDD VNW pm1p2_svt_lp W=300n L=60n MR=1
MPM0 net17 A0 net30 VNW pm1p2_svt_lp W=300n L=60n MR=1
MNM5 Y net22 VSS VPW nm1p2_svt_lp W=940e-9 L=60e-9 MR=1
MNM4 net22 net17 VSS VPW nm1p2_svt_lp W=470e-9 L=60e-9 MR=1
MNM3 net29 B1 VSS VPW nm1p2_svt_lp W=470e-9 L=60e-9 MR=1
MNM2 net22 B0 net29 VPW nm1p2_svt_lp W=470e-9 L=60e-9 MR=1
MNM1 net17 A1 VSS VPW nm1p2_svt_lp W=230n L=60n MR=1
MNM0 net17 A0 VSS VPW nm1p2_svt_lp W=230n L=60n MR=1
.ENDS
.SUBCKT MOAI22X4_9TSVT A0 A1 B0 B1 VDD VSS Y VNW VPW
MPM5 Y net22 VDD VNW pm1p2_svt_lp W=2.36e-6 L=60e-9 MR=1
MPM4 net23 net17 VDD VNW pm1p2_svt_lp W=1.18e-6 L=60e-9 MR=1
MPM3 net22 B1 net23 VNW pm1p2_svt_lp W=1.18e-6 L=60e-9 MR=1
MPM2 net22 B0 net23 VNW pm1p2_svt_lp W=1.18e-6 L=60e-9 MR=1
MPM1 net30 A1 VDD VNW pm1p2_svt_lp W=590e-9 L=60e-9 MR=1
MPM0 net17 A0 net30 VNW pm1p2_svt_lp W=590e-9 L=60e-9 MR=1
MNM5 Y net22 VSS VPW nm1p2_svt_lp W=1.88e-6 L=60e-9 MR=1
MNM4 net22 net17 VSS VPW nm1p2_svt_lp W=940e-9 L=60e-9 MR=1
MNM3 net29 B1 VSS VPW nm1p2_svt_lp W=940e-9 L=60e-9 MR=1
MNM2 net22 B0 net29 VPW nm1p2_svt_lp W=940e-9 L=60e-9 MR=1
MNM1 net17 A1 VSS VPW nm1p2_svt_lp W=470e-9 L=60e-9 MR=1
MNM0 net17 A0 VSS VPW nm1p2_svt_lp W=470e-9 L=60e-9 MR=1
.ENDS
.SUBCKT MX2X0P5_9TSVT A B S VDD VSS Y VNW VPW
MNM5 SN S VSS VPW nm1p2_svt_lp W=230e-9 L=60e-9 MR=1
MNM4 Y net23 VSS VPW nm1p2_svt_lp W=230e-9 L=60e-9 MR=1
MNM3 net23 S net15 VPW nm1p2_svt_lp W=230e-9 L=60e-9 MR=1
MNM2 net23 SN net17 VPW nm1p2_svt_lp W=230e-9 L=60e-9 MR=1
MNM1 net15 B VSS VPW nm1p2_svt_lp W=230e-9 L=60e-9 MR=1
MNM0 net17 A VSS VPW nm1p2_svt_lp W=230e-9 L=60e-9 MR=1
MPM5 SN S VDD VNW pm1p2_svt_lp W=300e-9 L=60e-9 MR=1
MPM4 Y net23 VDD VNW pm1p2_svt_lp W=300e-9 L=60e-9 MR=1
MPM3 net23 SN net15 VNW pm1p2_svt_lp W=300e-9 L=60e-9 MR=1
MPM2 net23 S net17 VNW pm1p2_svt_lp W=300e-9 L=60e-9 MR=1
MPM1 net15 B VDD VNW pm1p2_svt_lp W=300e-9 L=60e-9 MR=1
MPM0 net17 A VDD VNW pm1p2_svt_lp W=300e-9 L=60e-9 MR=1
.ENDS
.SUBCKT MX2X1_9TSVT A B S VDD VSS Y VNW VPW
MNM5 SN S VSS VPW nm1p2_svt_lp W=180e-9 L=60e-9 MR=1
MNM4 Y net23 VSS VPW nm1p2_svt_lp W=470e-9 L=60e-9 MR=1
MNM3 net23 S net15 VPW nm1p2_svt_lp W=230n L=60n MR=1
MNM2 net23 SN net17 VPW nm1p2_svt_lp W=230n L=60n MR=1
MNM1 net15 B VSS VPW nm1p2_svt_lp W=470e-9 L=60e-9 MR=1
MNM0 net17 A VSS VPW nm1p2_svt_lp W=470e-9 L=60e-9 MR=1
MPM5 SN S VDD VNW pm1p2_svt_lp W=300e-9 L=60e-9 MR=1
MPM4 Y net23 VDD VNW pm1p2_svt_lp W=590e-9 L=60e-9 MR=1
MPM3 net23 SN net15 VNW pm1p2_svt_lp W=300n L=60n MR=1
MPM2 net23 S net17 VNW pm1p2_svt_lp W=300n L=60n MR=1
MPM1 net15 B VDD VNW pm1p2_svt_lp W=590e-9 L=60e-9 MR=1
MPM0 net17 A VDD VNW pm1p2_svt_lp W=590e-9 L=60e-9 MR=1
.ENDS
.SUBCKT MX2X2_9TSVT A B S VDD VSS Y VNW VPW
MNM5 SN S VSS VPW nm1p2_svt_lp W=180e-9 L=60e-9 MR=1
MNM4 Y net23 VSS VPW nm1p2_svt_lp W=940e-9 L=60e-9 MR=1
MNM3 net23 S net15 VPW nm1p2_svt_lp W=470e-9 L=60e-9 MR=1
MNM2 net23 SN net17 VPW nm1p2_svt_lp W=470e-9 L=60e-9 MR=1
MNM1 net15 B VSS VPW nm1p2_svt_lp W=470e-9 L=60e-9 MR=1
MNM0 net17 A VSS VPW nm1p2_svt_lp W=470e-9 L=60e-9 MR=1
MPM5 SN S VDD VNW pm1p2_svt_lp W=300e-9 L=60e-9 MR=1
MPM4 Y net23 VDD VNW pm1p2_svt_lp W=1.18e-6 L=60e-9 MR=1
MPM3 net23 SN net15 VNW pm1p2_svt_lp W=590e-9 L=60e-9 MR=1
MPM2 net23 S net17 VNW pm1p2_svt_lp W=590e-9 L=60e-9 MR=1
MPM1 net15 B VDD VNW pm1p2_svt_lp W=590e-9 L=60e-9 MR=1
MPM0 net17 A VDD VNW pm1p2_svt_lp W=590e-9 L=60e-9 MR=1
.ENDS
.SUBCKT MX2X3_9TSVT A B S VDD VSS Y VNW VPW
MNM5 SN S VSS VPW nm1p2_svt_lp W=180e-9 L=60e-9 MR=1
MNM4 Y net23 VSS VPW nm1p2_svt_lp W=1.41e-6 L=60e-9 MR=1
MNM3 net23 S net15 VPW nm1p2_svt_lp W=470e-9 L=60e-9 MR=1
MNM2 net23 SN net17 VPW nm1p2_svt_lp W=470e-9 L=60e-9 MR=1
MNM1 net15 B VSS VPW nm1p2_svt_lp W=470e-9 L=60e-9 MR=1
MNM0 net17 A VSS VPW nm1p2_svt_lp W=470e-9 L=60e-9 MR=1
MPM5 SN S VDD VNW pm1p2_svt_lp W=300e-9 L=60e-9 MR=1
MPM4 Y net23 VDD VNW pm1p2_svt_lp W=1.77e-6 L=60e-9 MR=1
MPM3 net23 SN net15 VNW pm1p2_svt_lp W=590e-9 L=60e-9 MR=1
MPM2 net23 S net17 VNW pm1p2_svt_lp W=590e-9 L=60e-9 MR=1
MPM1 net15 B VDD VNW pm1p2_svt_lp W=590e-9 L=60e-9 MR=1
MPM0 net17 A VDD VNW pm1p2_svt_lp W=590e-9 L=60e-9 MR=1
.ENDS
.SUBCKT MX2X4_9TSVT A B S VDD VSS Y VNW VPW
MNM5 SN S VSS VPW nm1p2_svt_lp W=180e-9 L=60e-9 MR=1
MNM4 Y net23 VSS VPW nm1p2_svt_lp W=1.88e-6 L=60e-9 MR=1
MNM3 net23 S net15 VPW nm1p2_svt_lp W=470e-9 L=60e-9 MR=1
MNM2 net23 SN net17 VPW nm1p2_svt_lp W=470e-9 L=60e-9 MR=1
MNM1 net15 B VSS VPW nm1p2_svt_lp W=940e-9 L=60e-9 MR=1
MNM0 net17 A VSS VPW nm1p2_svt_lp W=940e-9 L=60e-9 MR=1
MPM5 SN S VDD VNW pm1p2_svt_lp W=300e-9 L=60e-9 MR=1
MPM4 Y net23 VDD VNW pm1p2_svt_lp W=2.36e-6 L=60e-9 MR=1
MPM3 net23 SN net15 VNW pm1p2_svt_lp W=590e-9 L=60e-9 MR=1
MPM2 net23 S net17 VNW pm1p2_svt_lp W=590e-9 L=60e-9 MR=1
MPM1 net15 B VDD VNW pm1p2_svt_lp W=1.18e-6 L=60e-9 MR=1
MPM0 net17 A VDD VNW pm1p2_svt_lp W=1.18e-6 L=60e-9 MR=1
.ENDS
.SUBCKT MX2X6_9TSVT A B S VDD VSS Y VNW VPW
MNM5 SN S VSS VPW nm1p2_svt_lp W=230n L=60n MR=1
MNM4 Y net23 VSS VPW nm1p2_svt_lp W=2.82e-6 L=60e-9 MR=1
MNM3 net23 S net15 VPW nm1p2_svt_lp W=470e-9 L=60e-9 MR=1
MNM2 net23 SN net17 VPW nm1p2_svt_lp W=470e-9 L=60e-9 MR=1
MNM1 net15 B VSS VPW nm1p2_svt_lp W=940e-9 L=60e-9 MR=1
MNM0 net17 A VSS VPW nm1p2_svt_lp W=940e-9 L=60e-9 MR=1
MPM5 SN S VDD VNW pm1p2_svt_lp W=300n L=60n MR=1
MPM4 Y net23 VDD VNW pm1p2_svt_lp W=3.54e-6 L=60e-9 MR=1
MPM3 net23 SN net15 VNW pm1p2_svt_lp W=590e-9 L=60e-9 MR=1
MPM2 net23 S net17 VNW pm1p2_svt_lp W=590e-9 L=60e-9 MR=1
MPM1 net15 B VDD VNW pm1p2_svt_lp W=1.18e-6 L=60e-9 MR=1
MPM0 net17 A VDD VNW pm1p2_svt_lp W=1.18e-6 L=60e-9 MR=1
.ENDS
.SUBCKT MX2X8_9TSVT A B S VDD VSS Y VNW VPW
MNM5 SN S VSS VPW nm1p2_svt_lp W=230n L=60n MR=1
MNM4 Y net23 VSS VPW nm1p2_svt_lp W=3.76e-6 L=60e-9 MR=1
MNM3 net23 S net15 VPW nm1p2_svt_lp W=470e-9 L=60e-9 MR=1
MNM2 net23 SN net17 VPW nm1p2_svt_lp W=470e-9 L=60e-9 MR=1
MNM1 net15 B VSS VPW nm1p2_svt_lp W=1.41e-6 L=60e-9 MR=1
MNM0 net17 A VSS VPW nm1p2_svt_lp W=1.41e-6 L=60e-9 MR=1
MPM5 SN S VDD VNW pm1p2_svt_lp W=300n L=60n MR=1
MPM4 Y net23 VDD VNW pm1p2_svt_lp W=4.72e-6 L=60e-9 MR=1
MPM3 net23 SN net15 VNW pm1p2_svt_lp W=590e-9 L=60e-9 MR=1
MPM2 net23 S net17 VNW pm1p2_svt_lp W=590e-9 L=60e-9 MR=1
MPM1 net15 B VDD VNW pm1p2_svt_lp W=1.77e-6 L=60e-9 MR=1
MPM0 net17 A VDD VNW pm1p2_svt_lp W=1.77e-6 L=60e-9 MR=1
.ENDS
.SUBCKT MX3X0P5_9TSVT A B C S0 S1 VDD VSS Y VNW VPW
MNM9 S1N S1 VSS VPW nm1p2_svt_lp W=230e-9 L=60e-9 MR=1
MNM8 S0N S0 VSS VPW nm1p2_svt_lp W=230e-9 L=60e-9 MR=1
MNM7 Y net38 VSS VPW nm1p2_svt_lp W=230e-9 L=60e-9 MR=1
MNM6 net38 S1 net20 VPW nm1p2_svt_lp W=230e-9 L=60e-9 MR=1
MNM5 net38 S1N net30 VPW nm1p2_svt_lp W=230e-9 L=60e-9 MR=1
MNM4 net30 S0 net22 VPW nm1p2_svt_lp W=230e-9 L=60e-9 MR=1
MNM3 net30 S0N net24 VPW nm1p2_svt_lp W=230e-9 L=60e-9 MR=1
MNM2 net20 C VSS VPW nm1p2_svt_lp W=230e-9 L=60e-9 MR=1
MNM1 net22 B VSS VPW nm1p2_svt_lp W=230e-9 L=60e-9 MR=1
MNM0 net24 A VSS VPW nm1p2_svt_lp W=230e-9 L=60e-9 MR=1
MPM9 S1N S1 VDD VNW pm1p2_svt_lp W=300e-9 L=60e-9 MR=1
MPM8 S0N S0 VDD VNW pm1p2_svt_lp W=300e-9 L=60e-9 MR=1
MPM7 Y net38 VDD VNW pm1p2_svt_lp W=300e-9 L=60e-9 MR=1
MPM6 net38 S1N net20 VNW pm1p2_svt_lp W=300e-9 L=60e-9 MR=1
MPM5 net38 S1 net30 VNW pm1p2_svt_lp W=300e-9 L=60e-9 MR=1
MPM4 net30 S0N net22 VNW pm1p2_svt_lp W=300e-9 L=60e-9 MR=1
MPM3 net30 S0 net24 VNW pm1p2_svt_lp W=300e-9 L=60e-9 MR=1
MPM2 net20 C VDD VNW pm1p2_svt_lp W=300e-9 L=60e-9 MR=1
MPM1 net22 B VDD VNW pm1p2_svt_lp W=300e-9 L=60e-9 MR=1
MPM0 net24 A VDD VNW pm1p2_svt_lp W=300e-9 L=60e-9 MR=1
.ENDS
.SUBCKT MX3X1_9TSVT A B C S0 S1 VDD VSS Y VNW VPW
MNM9 S1N S1 VSS VPW nm1p2_svt_lp W=230e-9 L=60e-9 MR=1
MNM8 S0N S0 VSS VPW nm1p2_svt_lp W=230e-9 L=60e-9 MR=1
MNM7 Y net38 VSS VPW nm1p2_svt_lp W=470e-9 L=60e-9 MR=1
MNM6 net38 S1 net20 VPW nm1p2_svt_lp W=230n L=60n MR=1
MNM5 net38 S1N net30 VPW nm1p2_svt_lp W=230n L=60n MR=1
MNM4 net30 S0 net22 VPW nm1p2_svt_lp W=230n L=60n MR=1
MNM3 net30 S0N net24 VPW nm1p2_svt_lp W=230n L=60n MR=1
MNM2 net20 C VSS VPW nm1p2_svt_lp W=470e-9 L=60e-9 MR=1
MNM1 net22 B VSS VPW nm1p2_svt_lp W=470e-9 L=60e-9 MR=1
MNM0 net24 A VSS VPW nm1p2_svt_lp W=470e-9 L=60e-9 MR=1
MPM9 S1N S1 VDD VNW pm1p2_svt_lp W=300e-9 L=60e-9 MR=1
MPM8 S0N S0 VDD VNW pm1p2_svt_lp W=300e-9 L=60e-9 MR=1
MPM7 Y net38 VDD VNW pm1p2_svt_lp W=590e-9 L=60e-9 MR=1
MPM6 net38 S1N net20 VNW pm1p2_svt_lp W=300n L=60n MR=1
MPM5 net38 S1 net30 VNW pm1p2_svt_lp W=300n L=60n MR=1
MPM4 net30 S0N net22 VNW pm1p2_svt_lp W=300n L=60n MR=1
MPM3 net30 S0 net24 VNW pm1p2_svt_lp W=300n L=60n MR=1
MPM2 net20 C VDD VNW pm1p2_svt_lp W=590e-9 L=60e-9 MR=1
MPM1 net22 B VDD VNW pm1p2_svt_lp W=590e-9 L=60e-9 MR=1
MPM0 net24 A VDD VNW pm1p2_svt_lp W=590e-9 L=60e-9 MR=1
.ENDS
.SUBCKT MX3X2_9TSVT A B C S0 S1 VDD VSS Y VNW VPW
MNM9 S1N S1 VSS VPW nm1p2_svt_lp W=230e-9 L=60e-9 MR=1
MNM8 S0N S0 VSS VPW nm1p2_svt_lp W=230e-9 L=60e-9 MR=1
MNM7 Y net38 VSS VPW nm1p2_svt_lp W=940e-9 L=60e-9 MR=1
MNM6 net38 S1 net20 VPW nm1p2_svt_lp W=470e-9 L=60e-9 MR=1
MNM5 net38 S1N net30 VPW nm1p2_svt_lp W=470e-9 L=60e-9 MR=1
MNM4 net30 S0 net22 VPW nm1p2_svt_lp W=470e-9 L=60e-9 MR=1
MNM3 net30 S0N net24 VPW nm1p2_svt_lp W=470e-9 L=60e-9 MR=1
MNM2 net20 C VSS VPW nm1p2_svt_lp W=470e-9 L=60e-9 MR=1
MNM1 net22 B VSS VPW nm1p2_svt_lp W=470e-9 L=60e-9 MR=1
MNM0 net24 A VSS VPW nm1p2_svt_lp W=470e-9 L=60e-9 MR=1
MPM9 S1N S1 VDD VNW pm1p2_svt_lp W=300e-9 L=60e-9 MR=1
MPM8 S0N S0 VDD VNW pm1p2_svt_lp W=300e-9 L=60e-9 MR=1
MPM7 Y net38 VDD VNW pm1p2_svt_lp W=1.18e-6 L=60e-9 MR=1
MPM6 net38 S1N net20 VNW pm1p2_svt_lp W=590e-9 L=60e-9 MR=1
MPM5 net38 S1 net30 VNW pm1p2_svt_lp W=590e-9 L=60e-9 MR=1
MPM4 net30 S0N net22 VNW pm1p2_svt_lp W=590e-9 L=60e-9 MR=1
MPM3 net30 S0 net24 VNW pm1p2_svt_lp W=590e-9 L=60e-9 MR=1
MPM2 net20 C VDD VNW pm1p2_svt_lp W=590e-9 L=60e-9 MR=1
MPM1 net22 B VDD VNW pm1p2_svt_lp W=590e-9 L=60e-9 MR=1
MPM0 net24 A VDD VNW pm1p2_svt_lp W=590e-9 L=60e-9 MR=1
.ENDS
.SUBCKT MX3X3_9TSVT A B C S0 S1 VDD VSS Y VNW VPW
MNM9 S1N S1 VSS VPW nm1p2_svt_lp W=230e-9 L=60e-9 MR=1
MNM8 S0N S0 VSS VPW nm1p2_svt_lp W=230e-9 L=60e-9 MR=1
MNM7 Y net38 VSS VPW nm1p2_svt_lp W=1.41e-6 L=60e-9 MR=1
MNM6 net38 S1 net20 VPW nm1p2_svt_lp W=470e-9 L=60e-9 MR=1
MNM5 net38 S1N net30 VPW nm1p2_svt_lp W=470e-9 L=60e-9 MR=1
MNM4 net30 S0 net22 VPW nm1p2_svt_lp W=470e-9 L=60e-9 MR=1
MNM3 net30 S0N net24 VPW nm1p2_svt_lp W=470e-9 L=60e-9 MR=1
MNM2 net20 C VSS VPW nm1p2_svt_lp W=470e-9 L=60e-9 MR=1
MNM1 net22 B VSS VPW nm1p2_svt_lp W=470e-9 L=60e-9 MR=1
MNM0 net24 A VSS VPW nm1p2_svt_lp W=470e-9 L=60e-9 MR=1
MPM9 S1N S1 VDD VNW pm1p2_svt_lp W=300e-9 L=60e-9 MR=1
MPM8 S0N S0 VDD VNW pm1p2_svt_lp W=300e-9 L=60e-9 MR=1
MPM7 Y net38 VDD VNW pm1p2_svt_lp W=1.77e-6 L=60e-9 MR=1
MPM6 net38 S1N net20 VNW pm1p2_svt_lp W=590e-9 L=60e-9 MR=1
MPM5 net38 S1 net30 VNW pm1p2_svt_lp W=590e-9 L=60e-9 MR=1
MPM4 net30 S0N net22 VNW pm1p2_svt_lp W=590e-9 L=60e-9 MR=1
MPM3 net30 S0 net24 VNW pm1p2_svt_lp W=590e-9 L=60e-9 MR=1
MPM2 net20 C VDD VNW pm1p2_svt_lp W=590e-9 L=60e-9 MR=1
MPM1 net22 B VDD VNW pm1p2_svt_lp W=590e-9 L=60e-9 MR=1
MPM0 net24 A VDD VNW pm1p2_svt_lp W=590e-9 L=60e-9 MR=1
.ENDS
.SUBCKT MX3X4_9TSVT A B C S0 S1 VDD VSS Y VNW VPW
MNM9 S1N S1 VSS VPW nm1p2_svt_lp W=230e-9 L=60e-9 MR=1
MNM8 S0N S0 VSS VPW nm1p2_svt_lp W=230e-9 L=60e-9 MR=1
MNM7 Y net38 VSS VPW nm1p2_svt_lp W=1.88e-6 L=60e-9 MR=1
MNM6 net38 S1 net20 VPW nm1p2_svt_lp W=470e-9 L=60e-9 MR=1
MNM5 net38 S1N net30 VPW nm1p2_svt_lp W=470e-9 L=60e-9 MR=1
MNM4 net30 S0 net22 VPW nm1p2_svt_lp W=470e-9 L=60e-9 MR=1
MNM3 net30 S0N net24 VPW nm1p2_svt_lp W=470e-9 L=60e-9 MR=1
MNM2 net20 C VSS VPW nm1p2_svt_lp W=940e-9 L=60e-9 MR=1
MNM1 net22 B VSS VPW nm1p2_svt_lp W=940e-9 L=60e-9 MR=1
MNM0 net24 A VSS VPW nm1p2_svt_lp W=940e-9 L=60e-9 MR=1
MPM9 S1N S1 VDD VNW pm1p2_svt_lp W=300e-9 L=60e-9 MR=1
MPM8 S0N S0 VDD VNW pm1p2_svt_lp W=300e-9 L=60e-9 MR=1
MPM7 Y net38 VDD VNW pm1p2_svt_lp W=2.36e-6 L=60e-9 MR=1
MPM6 net38 S1N net20 VNW pm1p2_svt_lp W=590e-9 L=60e-9 MR=1
MPM5 net38 S1 net30 VNW pm1p2_svt_lp W=590e-9 L=60e-9 MR=1
MPM4 net30 S0N net22 VNW pm1p2_svt_lp W=590e-9 L=60e-9 MR=1
MPM3 net30 S0 net24 VNW pm1p2_svt_lp W=590e-9 L=60e-9 MR=1
MPM2 net20 C VDD VNW pm1p2_svt_lp W=1.18e-6 L=60e-9 MR=1
MPM1 net22 B VDD VNW pm1p2_svt_lp W=1.18e-6 L=60e-9 MR=1
MPM0 net24 A VDD VNW pm1p2_svt_lp W=1.18e-6 L=60e-9 MR=1
.ENDS
.SUBCKT MX3X6_9TSVT A B C S0 S1 VDD VSS Y VNW VPW
MNM9 S1N S1 VSS VPW nm1p2_svt_lp W=230n L=60n MR=1
MNM8 S0N S0 VSS VPW nm1p2_svt_lp W=230n L=60n MR=1
MNM7 Y net38 VSS VPW nm1p2_svt_lp W=2.82e-6 L=60e-9 MR=1
MNM6 net38 S1 net20 VPW nm1p2_svt_lp W=470e-9 L=60e-9 MR=1
MNM5 net38 S1N net30 VPW nm1p2_svt_lp W=470e-9 L=60e-9 MR=1
MNM4 net30 S0 net22 VPW nm1p2_svt_lp W=470e-9 L=60e-9 MR=1
MNM3 net30 S0N net24 VPW nm1p2_svt_lp W=470e-9 L=60e-9 MR=1
MNM2 net20 C VSS VPW nm1p2_svt_lp W=940e-9 L=60e-9 MR=1
MNM1 net22 B VSS VPW nm1p2_svt_lp W=940e-9 L=60e-9 MR=1
MNM0 net24 A VSS VPW nm1p2_svt_lp W=940e-9 L=60e-9 MR=1
MPM9 S1N S1 VDD VNW pm1p2_svt_lp W=300n L=60n MR=1
MPM8 S0N S0 VDD VNW pm1p2_svt_lp W=300n L=60n MR=1
MPM7 Y net38 VDD VNW pm1p2_svt_lp W=3.54e-6 L=60e-9 MR=1
MPM6 net38 S1N net20 VNW pm1p2_svt_lp W=590e-9 L=60e-9 MR=1
MPM5 net38 S1 net30 VNW pm1p2_svt_lp W=590e-9 L=60e-9 MR=1
MPM4 net30 S0N net22 VNW pm1p2_svt_lp W=590e-9 L=60e-9 MR=1
MPM3 net30 S0 net24 VNW pm1p2_svt_lp W=590e-9 L=60e-9 MR=1
MPM2 net20 C VDD VNW pm1p2_svt_lp W=1.18e-6 L=60e-9 MR=1
MPM1 net22 B VDD VNW pm1p2_svt_lp W=1.18e-6 L=60e-9 MR=1
MPM0 net24 A VDD VNW pm1p2_svt_lp W=1.18e-6 L=60e-9 MR=1
.ENDS
.SUBCKT MX3X8_9TSVT A B C S0 S1 VDD VSS Y VNW VPW
MNM9 S1N S1 VSS VPW nm1p2_svt_lp W=230n L=60n MR=1
MNM8 S0N S0 VSS VPW nm1p2_svt_lp W=230n L=60n MR=1
MNM7 Y net38 VSS VPW nm1p2_svt_lp W=3.76e-6 L=60e-9 MR=1
MNM6 net38 S1 net20 VPW nm1p2_svt_lp W=470e-9 L=60e-9 MR=1
MNM5 net38 S1N net30 VPW nm1p2_svt_lp W=470e-9 L=60e-9 MR=1
MNM4 net30 S0 net22 VPW nm1p2_svt_lp W=470e-9 L=60e-9 MR=1
MNM3 net30 S0N net24 VPW nm1p2_svt_lp W=470e-9 L=60e-9 MR=1
MNM2 net20 C VSS VPW nm1p2_svt_lp W=1.41e-6 L=60e-9 MR=1
MNM1 net22 B VSS VPW nm1p2_svt_lp W=1.41e-6 L=60e-9 MR=1
MNM0 net24 A VSS VPW nm1p2_svt_lp W=1.41e-6 L=60e-9 MR=1
MPM9 S1N S1 VDD VNW pm1p2_svt_lp W=300n L=60n MR=1
MPM8 S0N S0 VDD VNW pm1p2_svt_lp W=300n L=60n MR=1
MPM7 Y net38 VDD VNW pm1p2_svt_lp W=4.72e-6 L=60e-9 MR=1
MPM6 net38 S1N net20 VNW pm1p2_svt_lp W=590e-9 L=60e-9 MR=1
MPM5 net38 S1 net30 VNW pm1p2_svt_lp W=590e-9 L=60e-9 MR=1
MPM4 net30 S0N net22 VNW pm1p2_svt_lp W=590e-9 L=60e-9 MR=1
MPM3 net30 S0 net24 VNW pm1p2_svt_lp W=590e-9 L=60e-9 MR=1
MPM2 net20 C VDD VNW pm1p2_svt_lp W=1.77e-6 L=60e-9 MR=1
MPM1 net22 B VDD VNW pm1p2_svt_lp W=1.77e-6 L=60e-9 MR=1
MPM0 net24 A VDD VNW pm1p2_svt_lp W=1.77e-6 L=60e-9 MR=1
.ENDS
.SUBCKT MX4X0P5_9TSVT A B C D S0 S1 VDD VSS Y VNW VPW
MNM12 S1N S1 VSS VPW nm1p2_svt_lp W=230e-9 L=60e-9 MR=1
MNM11 S0N S0 VSS VPW nm1p2_svt_lp W=230e-9 L=60e-9 MR=1
MNM10 Y net48 VSS VPW nm1p2_svt_lp W=230e-9 L=60e-9 MR=1
MNM9 net48 S1 net40 VPW nm1p2_svt_lp W=230e-9 L=60e-9 MR=1
MNM8 net48 S1N net39 VPW nm1p2_svt_lp W=230e-9 L=60e-9 MR=1
MNM7 net40 S0 net23 VPW nm1p2_svt_lp W=230e-9 L=60e-9 MR=1
MNM6 net40 S0N net25 VPW nm1p2_svt_lp W=230e-9 L=60e-9 MR=1
MNM5 net39 S0 net27 VPW nm1p2_svt_lp W=230e-9 L=60e-9 MR=1
MNM4 net39 S0N net29 VPW nm1p2_svt_lp W=230e-9 L=60e-9 MR=1
MNM3 net23 D VSS VPW nm1p2_svt_lp W=230e-9 L=60e-9 MR=1
MNM2 net25 C VSS VPW nm1p2_svt_lp W=230e-9 L=60e-9 MR=1
MNM1 net27 B VSS VPW nm1p2_svt_lp W=230e-9 L=60e-9 MR=1
MNM0 net29 A VSS VPW nm1p2_svt_lp W=230e-9 L=60e-9 MR=1
MPM12 S1N S1 VDD VNW pm1p2_svt_lp W=300e-9 L=60e-9 MR=1
MPM11 S0N S0 VDD VNW pm1p2_svt_lp W=300e-9 L=60e-9 MR=1
MPM10 Y net48 VDD VNW pm1p2_svt_lp W=300e-9 L=60e-9 MR=1
MPM9 net48 S1N net40 VNW pm1p2_svt_lp W=275e-9 L=60e-9 MR=1
MPM8 net48 S1 net39 VNW pm1p2_svt_lp W=300e-9 L=60e-9 MR=1
MPM7 net40 S0N net23 VNW pm1p2_svt_lp W=300e-9 L=60e-9 MR=1
MPM6 net40 S0 net25 VNW pm1p2_svt_lp W=300e-9 L=60e-9 MR=1
MPM5 net39 S0N net27 VNW pm1p2_svt_lp W=300e-9 L=60e-9 MR=1
MPM4 net39 S0 net29 VNW pm1p2_svt_lp W=300e-9 L=60e-9 MR=1
MPM3 net23 D VDD VNW pm1p2_svt_lp W=300e-9 L=60e-9 MR=1
MPM2 net25 C VDD VNW pm1p2_svt_lp W=300e-9 L=60e-9 MR=1
MPM1 net27 B VDD VNW pm1p2_svt_lp W=300e-9 L=60e-9 MR=1
MPM0 net29 A VDD VNW pm1p2_svt_lp W=300e-9 L=60e-9 MR=1
.ENDS
.SUBCKT MX4X1_9TSVT A B C D S0 S1 VDD VSS Y VNW VPW
MNM12 S1N S1 VSS VPW nm1p2_svt_lp W=230e-9 L=60e-9 MR=1
MNM11 S0N S0 VSS VPW nm1p2_svt_lp W=230e-9 L=60e-9 MR=1
MNM10 Y net48 VSS VPW nm1p2_svt_lp W=470e-9 L=60e-9 MR=1
MNM9 net48 S1 net40 VPW nm1p2_svt_lp W=230n L=60n MR=1
MNM8 net48 S1N net39 VPW nm1p2_svt_lp W=230n L=60n MR=1
MNM7 net40 S0 net23 VPW nm1p2_svt_lp W=230n L=60n MR=1
MNM6 net40 S0N net25 VPW nm1p2_svt_lp W=230n L=60n MR=1
MNM5 net39 S0 net27 VPW nm1p2_svt_lp W=230n L=60n MR=1
MNM4 net39 S0N net29 VPW nm1p2_svt_lp W=230n L=60n MR=1
MNM3 net23 D VSS VPW nm1p2_svt_lp W=470e-9 L=60e-9 MR=1
MNM2 net25 C VSS VPW nm1p2_svt_lp W=470e-9 L=60e-9 MR=1
MNM1 net27 B VSS VPW nm1p2_svt_lp W=470e-9 L=60e-9 MR=1
MNM0 net29 A VSS VPW nm1p2_svt_lp W=470e-9 L=60e-9 MR=1
MPM12 S1N S1 VDD VNW pm1p2_svt_lp W=300e-9 L=60e-9 MR=1
MPM11 S0N S0 VDD VNW pm1p2_svt_lp W=300e-9 L=60e-9 MR=1
MPM10 Y net48 VDD VNW pm1p2_svt_lp W=590e-9 L=60e-9 MR=1
MPM9 net48 S1N net40 VNW pm1p2_svt_lp W=275n L=60n MR=1
MPM8 net48 S1 net39 VNW pm1p2_svt_lp W=300n L=60n MR=1
MPM7 net40 S0N net23 VNW pm1p2_svt_lp W=300n L=60n MR=1
MPM6 net40 S0 net25 VNW pm1p2_svt_lp W=300n L=60n MR=1
MPM5 net39 S0N net27 VNW pm1p2_svt_lp W=300n L=60n MR=1
MPM4 net39 S0 net29 VNW pm1p2_svt_lp W=300n L=60n MR=1
MPM3 net23 D VDD VNW pm1p2_svt_lp W=410e-9 L=60e-9 MR=1
MPM2 net25 C VDD VNW pm1p2_svt_lp W=590e-9 L=60e-9 MR=1
MPM1 net27 B VDD VNW pm1p2_svt_lp W=410e-9 L=60e-9 MR=1
MPM0 net29 A VDD VNW pm1p2_svt_lp W=590e-9 L=60e-9 MR=1
.ENDS
.SUBCKT MX4X2_9TSVT A B C D S0 S1 VDD VSS Y VNW VPW
MNM12 S1N S1 VSS VPW nm1p2_svt_lp W=230e-9 L=60e-9 MR=1
MNM11 S0N S0 VSS VPW nm1p2_svt_lp W=230e-9 L=60e-9 MR=1
MNM10 Y net48 VSS VPW nm1p2_svt_lp W=940e-9 L=60e-9 MR=1
MNM9 net48 S1 net40 VPW nm1p2_svt_lp W=470e-9 L=60e-9 MR=1
MNM8 net48 S1N net39 VPW nm1p2_svt_lp W=470e-9 L=60e-9 MR=1
MNM7 net40 S0 net23 VPW nm1p2_svt_lp W=470e-9 L=60e-9 MR=1
MNM6 net40 S0N net25 VPW nm1p2_svt_lp W=470e-9 L=60e-9 MR=1
MNM5 net39 S0 net27 VPW nm1p2_svt_lp W=470e-9 L=60e-9 MR=1
MNM4 net39 S0N net29 VPW nm1p2_svt_lp W=470e-9 L=60e-9 MR=1
MNM3 net23 D VSS VPW nm1p2_svt_lp W=470e-9 L=60e-9 MR=1
MNM2 net25 C VSS VPW nm1p2_svt_lp W=470e-9 L=60e-9 MR=1
MNM1 net27 B VSS VPW nm1p2_svt_lp W=470e-9 L=60e-9 MR=1
MNM0 net29 A VSS VPW nm1p2_svt_lp W=470e-9 L=60e-9 MR=1
MPM12 S1N S1 VDD VNW pm1p2_svt_lp W=300e-9 L=60e-9 MR=1
MPM11 S0N S0 VDD VNW pm1p2_svt_lp W=300e-9 L=60e-9 MR=1
MPM10 Y net48 VDD VNW pm1p2_svt_lp W=1.18e-6 L=60e-9 MR=1
MPM9 net48 S1N net40 VNW pm1p2_svt_lp W=275e-9 L=60e-9 MR=1
MPM8 net48 S1 net39 VNW pm1p2_svt_lp W=590e-9 L=60e-9 MR=1
MPM7 net40 S0N net23 VNW pm1p2_svt_lp W=590e-9 L=60e-9 MR=1
MPM6 net40 S0 net25 VNW pm1p2_svt_lp W=590e-9 L=60e-9 MR=1
MPM5 net39 S0N net27 VNW pm1p2_svt_lp W=590e-9 L=60e-9 MR=1
MPM4 net39 S0 net29 VNW pm1p2_svt_lp W=590e-9 L=60e-9 MR=1
MPM3 net23 D VDD VNW pm1p2_svt_lp W=410e-9 L=60e-9 MR=1
MPM2 net25 C VDD VNW pm1p2_svt_lp W=590e-9 L=60e-9 MR=1
MPM1 net27 B VDD VNW pm1p2_svt_lp W=380e-9 L=60e-9 MR=1
MPM0 net29 A VDD VNW pm1p2_svt_lp W=590e-9 L=60e-9 MR=1
.ENDS
.SUBCKT MX4X3_9TSVT A B C D S0 S1 VDD VSS Y VNW VPW
MNM12 S1N S1 VSS VPW nm1p2_svt_lp W=230e-9 L=60e-9 MR=1
MNM11 S0N S0 VSS VPW nm1p2_svt_lp W=230e-9 L=60e-9 MR=1
MNM10 Y net48 VSS VPW nm1p2_svt_lp W=1.41e-6 L=60e-9 MR=1
MNM9 net48 S1 net40 VPW nm1p2_svt_lp W=470e-9 L=60e-9 MR=1
MNM8 net48 S1N net39 VPW nm1p2_svt_lp W=470e-9 L=60e-9 MR=1
MNM7 net40 S0 net23 VPW nm1p2_svt_lp W=470e-9 L=60e-9 MR=1
MNM6 net40 S0N net25 VPW nm1p2_svt_lp W=470e-9 L=60e-9 MR=1
MNM5 net39 S0 net27 VPW nm1p2_svt_lp W=470e-9 L=60e-9 MR=1
MNM4 net39 S0N net29 VPW nm1p2_svt_lp W=470e-9 L=60e-9 MR=1
MNM3 net23 D VSS VPW nm1p2_svt_lp W=470e-9 L=60e-9 MR=1
MNM2 net25 C VSS VPW nm1p2_svt_lp W=470e-9 L=60e-9 MR=1
MNM1 net27 B VSS VPW nm1p2_svt_lp W=470e-9 L=60e-9 MR=1
MNM0 net29 A VSS VPW nm1p2_svt_lp W=470e-9 L=60e-9 MR=1
MPM12 S1N S1 VDD VNW pm1p2_svt_lp W=300e-9 L=60e-9 MR=1
MPM11 S0N S0 VDD VNW pm1p2_svt_lp W=300e-9 L=60e-9 MR=1
MPM10 Y net48 VDD VNW pm1p2_svt_lp W=1.77e-6 L=60e-9 MR=1
MPM9 net48 S1N net40 VNW pm1p2_svt_lp W=275e-9 L=60e-9 MR=1
MPM8 net48 S1 net39 VNW pm1p2_svt_lp W=590e-9 L=60e-9 MR=1
MPM7 net40 S0N net23 VNW pm1p2_svt_lp W=590e-9 L=60e-9 MR=1
MPM6 net40 S0 net25 VNW pm1p2_svt_lp W=590e-9 L=60e-9 MR=1
MPM5 net39 S0N net27 VNW pm1p2_svt_lp W=590e-9 L=60e-9 MR=1
MPM4 net39 S0 net29 VNW pm1p2_svt_lp W=590e-9 L=60e-9 MR=1
MPM3 net23 D VDD VNW pm1p2_svt_lp W=410e-9 L=60e-9 MR=1
MPM2 net25 C VDD VNW pm1p2_svt_lp W=590e-9 L=60e-9 MR=1
MPM1 net27 B VDD VNW pm1p2_svt_lp W=380e-9 L=60e-9 MR=1
MPM0 net29 A VDD VNW pm1p2_svt_lp W=590e-9 L=60e-9 MR=1
.ENDS
.SUBCKT MX4X4_9TSVT A B C D S0 S1 VDD VSS Y VNW VPW
MNM12 S1N S1 VSS VPW nm1p2_svt_lp W=230e-9 L=60e-9 MR=1
MNM11 S0N S0 VSS VPW nm1p2_svt_lp W=230e-9 L=60e-9 MR=1
MNM10 Y net48 VSS VPW nm1p2_svt_lp W=1.88e-6 L=60e-9 MR=1
MNM9 net48 S1 net40 VPW nm1p2_svt_lp W=470e-9 L=60e-9 MR=1
MNM8 net48 S1N net39 VPW nm1p2_svt_lp W=470e-9 L=60e-9 MR=1
MNM7 net40 S0 net23 VPW nm1p2_svt_lp W=470e-9 L=60e-9 MR=1
MNM6 net40 S0N net25 VPW nm1p2_svt_lp W=470e-9 L=60e-9 MR=1
MNM5 net39 S0 net27 VPW nm1p2_svt_lp W=470e-9 L=60e-9 MR=1
MNM4 net39 S0N net29 VPW nm1p2_svt_lp W=470e-9 L=60e-9 MR=1
MNM3 net23 D VSS VPW nm1p2_svt_lp W=940e-9 L=60e-9 MR=1
MNM2 net25 C VSS VPW nm1p2_svt_lp W=940e-9 L=60e-9 MR=1
MNM1 net27 B VSS VPW nm1p2_svt_lp W=940e-9 L=60e-9 MR=1
MNM0 net29 A VSS VPW nm1p2_svt_lp W=940e-9 L=60e-9 MR=1
MPM12 S1N S1 VDD VNW pm1p2_svt_lp W=300e-9 L=60e-9 MR=1
MPM11 S0N S0 VDD VNW pm1p2_svt_lp W=300e-9 L=60e-9 MR=1
MPM10 Y net48 VDD VNW pm1p2_svt_lp W=2.36e-6 L=60e-9 MR=1
MPM9 net48 S1N net40 VNW pm1p2_svt_lp W=590e-9 L=60e-9 MR=1
MPM8 net48 S1 net39 VNW pm1p2_svt_lp W=590e-9 L=60e-9 MR=1
MPM7 net40 S0N net23 VNW pm1p2_svt_lp W=300e-9 L=60e-9 MR=1
MPM6 net40 S0 net25 VNW pm1p2_svt_lp W=410e-9 L=60e-9 MR=1
MPM5 net39 S0N net27 VNW pm1p2_svt_lp W=590e-9 L=60e-9 MR=1
MPM4 net39 S0 net29 VNW pm1p2_svt_lp W=590e-9 L=60e-9 MR=1
MPM3 net23 D VDD VNW pm1p2_svt_lp W=0.78e-6 L=60e-9 MR=1
MPM2 net25 C VDD VNW pm1p2_svt_lp W=1.18e-6 L=60e-9 MR=1
MPM1 net27 B VDD VNW pm1p2_svt_lp W=0.82e-6 L=60e-9 MR=1
MPM0 net29 A VDD VNW pm1p2_svt_lp W=1.18e-6 L=60e-9 MR=1
.ENDS
.SUBCKT MX4X6_9TSVT A B C D S0 S1 VDD VSS Y VNW VPW
MNM12 S1N S1 VSS VPW nm1p2_svt_lp W=230n L=60n MR=1
MNM11 S0N S0 VSS VPW nm1p2_svt_lp W=230n L=60n MR=1
MNM10 Y net48 VSS VPW nm1p2_svt_lp W=2.82e-6 L=60e-9 MR=1
MNM9 net48 S1 net40 VPW nm1p2_svt_lp W=470e-9 L=60e-9 MR=1
MNM8 net48 S1N net39 VPW nm1p2_svt_lp W=470e-9 L=60e-9 MR=1
MNM7 net40 S0 net23 VPW nm1p2_svt_lp W=470e-9 L=60e-9 MR=1
MNM6 net40 S0N net25 VPW nm1p2_svt_lp W=470e-9 L=60e-9 MR=1
MNM5 net39 S0 net27 VPW nm1p2_svt_lp W=470e-9 L=60e-9 MR=1
MNM4 net39 S0N net29 VPW nm1p2_svt_lp W=470e-9 L=60e-9 MR=1
MNM3 net23 D VSS VPW nm1p2_svt_lp W=940e-9 L=60e-9 MR=1
MNM2 net25 C VSS VPW nm1p2_svt_lp W=940e-9 L=60e-9 MR=1
MNM1 net27 B VSS VPW nm1p2_svt_lp W=940e-9 L=60e-9 MR=1
MNM0 net29 A VSS VPW nm1p2_svt_lp W=940e-9 L=60e-9 MR=1
MPM12 S1N S1 VDD VNW pm1p2_svt_lp W=300n L=60n MR=1
MPM11 S0N S0 VDD VNW pm1p2_svt_lp W=300n L=60n MR=1
MPM10 Y net48 VDD VNW pm1p2_svt_lp W=3.54e-6 L=60e-9 MR=1
MPM9 net48 S1N net40 VNW pm1p2_svt_lp W=590e-9 L=60e-9 MR=1
MPM8 net48 S1 net39 VNW pm1p2_svt_lp W=590e-9 L=60e-9 MR=1
MPM7 net40 S0N net23 VNW pm1p2_svt_lp W=320e-9 L=60e-9 MR=1
MPM6 net40 S0 net25 VNW pm1p2_svt_lp W=410e-9 L=60e-9 MR=1
MPM5 net39 S0N net27 VNW pm1p2_svt_lp W=590e-9 L=60e-9 MR=1
MPM4 net39 S0 net29 VNW pm1p2_svt_lp W=590e-9 L=60e-9 MR=1
MPM3 net23 D VDD VNW pm1p2_svt_lp W=0.78e-6 L=60e-9 MR=1
MPM2 net25 C VDD VNW pm1p2_svt_lp W=1.18e-6 L=60e-9 MR=1
MPM1 net27 B VDD VNW pm1p2_svt_lp W=0.82e-6 L=60e-9 MR=1
MPM0 net29 A VDD VNW pm1p2_svt_lp W=1.18e-6 L=60e-9 MR=1
.ENDS
.SUBCKT MX4X8_9TSVT A B C D S0 S1 VDD VSS Y VNW VPW
MNM12 S1N S1 VSS VPW nm1p2_svt_lp W=470e-9 L=60e-9 MR=1
MNM11 S0N S0 VSS VPW nm1p2_svt_lp W=470e-9 L=60e-9 MR=1
MNM10 Y net48 VSS VPW nm1p2_svt_lp W=3.76e-6 L=60e-9 MR=1
MNM9 net48 S1 net40 VPW nm1p2_svt_lp W=470e-9 L=60e-9 MR=1
MNM8 net48 S1N net39 VPW nm1p2_svt_lp W=470e-9 L=60e-9 MR=1
MNM7 net40 S0 net23 VPW nm1p2_svt_lp W=470e-9 L=60e-9 MR=1
MNM6 net40 S0N net25 VPW nm1p2_svt_lp W=470e-9 L=60e-9 MR=1
MNM5 net39 S0 net27 VPW nm1p2_svt_lp W=470e-9 L=60e-9 MR=1
MNM4 net39 S0N net29 VPW nm1p2_svt_lp W=470e-9 L=60e-9 MR=1
MNM3 net23 D VSS VPW nm1p2_svt_lp W=1.41e-6 L=60e-9 MR=1
MNM2 net25 C VSS VPW nm1p2_svt_lp W=1.41e-6 L=60e-9 MR=1
MNM1 net27 B VSS VPW nm1p2_svt_lp W=1.41e-6 L=60e-9 MR=1
MNM0 net29 A VSS VPW nm1p2_svt_lp W=1.41e-6 L=60e-9 MR=1
MPM12 S1N S1 VDD VNW pm1p2_svt_lp W=590e-9 L=60e-9 MR=1
MPM11 S0N S0 VDD VNW pm1p2_svt_lp W=410e-9 L=60e-9 MR=1
MPM10 Y net48 VDD VNW pm1p2_svt_lp W=4.72e-6 L=60e-9 MR=1
MPM9 net48 S1N net40 VNW pm1p2_svt_lp W=590e-9 L=60e-9 MR=1
MPM8 net48 S1 net39 VNW pm1p2_svt_lp W=590e-9 L=60e-9 MR=1
MPM7 net40 S0N net23 VNW pm1p2_svt_lp W=410e-9 L=60e-9 MR=1
MPM6 net40 S0 net25 VNW pm1p2_svt_lp W=410e-9 L=60e-9 MR=1
MPM5 net39 S0N net27 VNW pm1p2_svt_lp W=590e-9 L=60e-9 MR=1
MPM4 net39 S0 net29 VNW pm1p2_svt_lp W=590e-9 L=60e-9 MR=1
MPM3 net23 D VDD VNW pm1p2_svt_lp W=1.23e-6 L=60e-9 MR=1
MPM2 net25 C VDD VNW pm1p2_svt_lp W=1.77e-6 L=60e-9 MR=1
MPM1 net27 B VDD VNW pm1p2_svt_lp W=1.23e-6 L=60e-9 MR=1
MPM0 net29 A VDD VNW pm1p2_svt_lp W=1.77e-6 L=60e-9 MR=1
.ENDS
.SUBCKT MXI2X0P5_9TSVT A B S VDD VSS Y VNW VPW
MNM6 SN S VSS VPW nm1p2_svt_lp W=230e-9 L=60e-9 MR=1
MNM5 Y net27 VSS VPW nm1p2_svt_lp W=230e-9 L=60e-9 MR=1
MNM4 net27 net23 VSS VPW nm1p2_svt_lp W=230e-9 L=60e-9 MR=1
MNM3 net23 S net15 VPW nm1p2_svt_lp W=230e-9 L=60e-9 MR=1
MNM2 net23 SN net17 VPW nm1p2_svt_lp W=230e-9 L=60e-9 MR=1
MNM1 net15 B VSS VPW nm1p2_svt_lp W=230e-9 L=60e-9 MR=1
MNM0 net17 A VSS VPW nm1p2_svt_lp W=230e-9 L=60e-9 MR=1
MPM6 SN S VDD VNW pm1p2_svt_lp W=300e-9 L=60e-9 MR=1
MPM5 Y net27 VDD VNW pm1p2_svt_lp W=300e-9 L=60e-9 MR=1
MPM4 net27 net23 VDD VNW pm1p2_svt_lp W=300e-9 L=60e-9 MR=1
MPM3 net23 SN net15 VNW pm1p2_svt_lp W=300e-9 L=60e-9 MR=1
MPM2 net23 S net17 VNW pm1p2_svt_lp W=300e-9 L=60e-9 MR=1
MPM1 net15 B VDD VNW pm1p2_svt_lp W=300e-9 L=60e-9 MR=1
MPM0 net17 A VDD VNW pm1p2_svt_lp W=300e-9 L=60e-9 MR=1
.ENDS
.SUBCKT MXI2X1_9TSVT A B S VDD VSS Y VNW VPW
MNM6 SN S VSS VPW nm1p2_svt_lp W=230n L=60n MR=1
MNM5 Y net27 VSS VPW nm1p2_svt_lp W=470e-9 L=60e-9 MR=1
MNM4 net27 net23 VSS VPW nm1p2_svt_lp W=470e-9 L=60e-9 MR=1
MNM3 net23 S net15 VPW nm1p2_svt_lp W=230n L=60n MR=1
MNM2 net23 SN net17 VPW nm1p2_svt_lp W=230n L=60n MR=1
MNM1 net15 B VSS VPW nm1p2_svt_lp W=470e-9 L=60e-9 MR=1
MNM0 net17 A VSS VPW nm1p2_svt_lp W=470e-9 L=60e-9 MR=1
MPM6 SN S VDD VNW pm1p2_svt_lp W=300e-9 L=60e-9 MR=1
MPM5 Y net27 VDD VNW pm1p2_svt_lp W=590e-9 L=60e-9 MR=1
MPM4 net27 net23 VDD VNW pm1p2_svt_lp W=590e-9 L=60e-9 MR=1
MPM3 net23 SN net15 VNW pm1p2_svt_lp W=300n L=60n MR=1
MPM2 net23 S net17 VNW pm1p2_svt_lp W=300n L=60n MR=1
MPM1 net15 B VDD VNW pm1p2_svt_lp W=590e-9 L=60e-9 MR=1
MPM0 net17 A VDD VNW pm1p2_svt_lp W=590e-9 L=60e-9 MR=1
.ENDS
.SUBCKT MXI2X2_9TSVT A B S VDD VSS Y VNW VPW
MNM6 SN S VSS VPW nm1p2_svt_lp W=180e-9 L=60e-9 MR=1
MNM5 Y net27 VSS VPW nm1p2_svt_lp W=940e-9 L=60e-9 MR=1
MNM4 net27 net23 VSS VPW nm1p2_svt_lp W=470e-9 L=60e-9 MR=1
MNM3 net23 S net15 VPW nm1p2_svt_lp W=470e-9 L=60e-9 MR=1
MNM2 net23 SN net17 VPW nm1p2_svt_lp W=470e-9 L=60e-9 MR=1
MNM1 net15 B VSS VPW nm1p2_svt_lp W=470e-9 L=60e-9 MR=1
MNM0 net17 A VSS VPW nm1p2_svt_lp W=470e-9 L=60e-9 MR=1
MPM6 SN S VDD VNW pm1p2_svt_lp W=300e-9 L=60e-9 MR=1
MPM5 Y net27 VDD VNW pm1p2_svt_lp W=1.18e-6 L=60e-9 MR=1
MPM4 net27 net23 VDD VNW pm1p2_svt_lp W=590e-9 L=60e-9 MR=1
MPM3 net23 SN net15 VNW pm1p2_svt_lp W=590e-9 L=60e-9 MR=1
MPM2 net23 S net17 VNW pm1p2_svt_lp W=590e-9 L=60e-9 MR=1
MPM1 net15 B VDD VNW pm1p2_svt_lp W=590e-9 L=60e-9 MR=1
MPM0 net17 A VDD VNW pm1p2_svt_lp W=590e-9 L=60e-9 MR=1
.ENDS
.SUBCKT MXI2X3_9TSVT A B S VDD VSS Y VNW VPW
MNM6 SN S VSS VPW nm1p2_svt_lp W=180e-9 L=60e-9 MR=1
MNM5 Y net27 VSS VPW nm1p2_svt_lp W=1.41e-6 L=60e-9 MR=1
MNM4 net27 net23 VSS VPW nm1p2_svt_lp W=470e-9 L=60e-9 MR=1
MNM3 net23 S net15 VPW nm1p2_svt_lp W=470e-9 L=60e-9 MR=1
MNM2 net23 SN net17 VPW nm1p2_svt_lp W=470e-9 L=60e-9 MR=1
MNM1 net15 B VSS VPW nm1p2_svt_lp W=470e-9 L=60e-9 MR=1
MNM0 net17 A VSS VPW nm1p2_svt_lp W=470e-9 L=60e-9 MR=1
MPM6 SN S VDD VNW pm1p2_svt_lp W=300e-9 L=60e-9 MR=1
MPM5 Y net27 VDD VNW pm1p2_svt_lp W=1.77e-6 L=60e-9 MR=1
MPM4 net27 net23 VDD VNW pm1p2_svt_lp W=590e-9 L=60e-9 MR=1
MPM3 net23 SN net15 VNW pm1p2_svt_lp W=590e-9 L=60e-9 MR=1
MPM2 net23 S net17 VNW pm1p2_svt_lp W=590e-9 L=60e-9 MR=1
MPM1 net15 B VDD VNW pm1p2_svt_lp W=590e-9 L=60e-9 MR=1
MPM0 net17 A VDD VNW pm1p2_svt_lp W=590e-9 L=60e-9 MR=1
.ENDS
.SUBCKT MXI2X4_9TSVT A B S VDD VSS Y VNW VPW
MNM6 SN S VSS VPW nm1p2_svt_lp W=180e-9 L=60e-9 MR=1
MNM5 Y net27 VSS VPW nm1p2_svt_lp W=1.88e-6 L=60e-9 MR=1
MNM4 net27 net23 VSS VPW nm1p2_svt_lp W=940e-9 L=60e-9 MR=1
MNM3 net23 S net15 VPW nm1p2_svt_lp W=470e-9 L=60e-9 MR=1
MNM2 net23 SN net17 VPW nm1p2_svt_lp W=470e-9 L=60e-9 MR=1
MNM1 net15 B VSS VPW nm1p2_svt_lp W=470e-9 L=60e-9 MR=1
MNM0 net17 A VSS VPW nm1p2_svt_lp W=470e-9 L=60e-9 MR=1
MPM6 SN S VDD VNW pm1p2_svt_lp W=300e-9 L=60e-9 MR=1
MPM5 Y net27 VDD VNW pm1p2_svt_lp W=2.36e-6 L=60e-9 MR=1
MPM4 net27 net23 VDD VNW pm1p2_svt_lp W=1.18e-6 L=60e-9 MR=1
MPM3 net23 SN net15 VNW pm1p2_svt_lp W=590e-9 L=60e-9 MR=1
MPM2 net23 S net17 VNW pm1p2_svt_lp W=590e-9 L=60e-9 MR=1
MPM1 net15 B VDD VNW pm1p2_svt_lp W=590e-9 L=60e-9 MR=1
MPM0 net17 A VDD VNW pm1p2_svt_lp W=590e-9 L=60e-9 MR=1
.ENDS
.SUBCKT MXI2X6_9TSVT A B S VDD VSS Y VNW VPW
MNM6 SN S VSS VPW nm1p2_svt_lp W=230n L=60n MR=1
MNM5 Y net27 VSS VPW nm1p2_svt_lp W=2.82e-6 L=60e-9 MR=1
MNM4 net27 net23 VSS VPW nm1p2_svt_lp W=940e-9 L=60e-9 MR=1
MNM3 net23 S net15 VPW nm1p2_svt_lp W=470e-9 L=60e-9 MR=1
MNM2 net23 SN net17 VPW nm1p2_svt_lp W=470e-9 L=60e-9 MR=1
MNM1 net15 B VSS VPW nm1p2_svt_lp W=470e-9 L=60e-9 MR=1
MNM0 net17 A VSS VPW nm1p2_svt_lp W=470e-9 L=60e-9 MR=1
MPM6 SN S VDD VNW pm1p2_svt_lp W=300n L=60n MR=1
MPM5 Y net27 VDD VNW pm1p2_svt_lp W=3.54e-6 L=60e-9 MR=1
MPM4 net27 net23 VDD VNW pm1p2_svt_lp W=1.18e-6 L=60e-9 MR=1
MPM3 net23 SN net15 VNW pm1p2_svt_lp W=590e-9 L=60e-9 MR=1
MPM2 net23 S net17 VNW pm1p2_svt_lp W=590e-9 L=60e-9 MR=1
MPM1 net15 B VDD VNW pm1p2_svt_lp W=590e-9 L=60e-9 MR=1
MPM0 net17 A VDD VNW pm1p2_svt_lp W=590e-9 L=60e-9 MR=1
.ENDS
.SUBCKT MXI2X8_9TSVT A B S VDD VSS Y VNW VPW
MNM6 SN S VSS VPW nm1p2_svt_lp W=230n L=60n MR=1
MNM5 Y net27 VSS VPW nm1p2_svt_lp W=3.76e-6 L=60e-9 MR=1
MNM4 net27 net23 VSS VPW nm1p2_svt_lp W=1.41e-6 L=60e-9 MR=1
MNM3 net23 S net15 VPW nm1p2_svt_lp W=470e-9 L=60e-9 MR=1
MNM2 net23 SN net17 VPW nm1p2_svt_lp W=470e-9 L=60e-9 MR=1
MNM1 net15 B VSS VPW nm1p2_svt_lp W=470e-9 L=60e-9 MR=1
MNM0 net17 A VSS VPW nm1p2_svt_lp W=470e-9 L=60e-9 MR=1
MPM6 SN S VDD VNW pm1p2_svt_lp W=300n L=60n MR=1
MPM5 Y net27 VDD VNW pm1p2_svt_lp W=4.72e-6 L=60e-9 MR=1
MPM4 net27 net23 VDD VNW pm1p2_svt_lp W=1.77e-6 L=60e-9 MR=1
MPM3 net23 SN net15 VNW pm1p2_svt_lp W=590e-9 L=60e-9 MR=1
MPM2 net23 S net17 VNW pm1p2_svt_lp W=590e-9 L=60e-9 MR=1
MPM1 net15 B VDD VNW pm1p2_svt_lp W=590e-9 L=60e-9 MR=1
MPM0 net17 A VDD VNW pm1p2_svt_lp W=590e-9 L=60e-9 MR=1
.ENDS
.SUBCKT MXI3X0P5_9TSVT A B C S0 S1 VDD VSS Y VNW VPW
MNM10 S1N S1 VSS VPW nm1p2_svt_lp W=230e-9 L=60e-9 MR=1
MNM9 S0N S0 VSS VPW nm1p2_svt_lp W=230e-9 L=60e-9 MR=1
MNM8 Y net42 VSS VPW nm1p2_svt_lp W=230e-9 L=60e-9 MR=1
MNM7 net42 net38 VSS VPW nm1p2_svt_lp W=230e-9 L=60e-9 MR=1
MNM6 net38 S1 net20 VPW nm1p2_svt_lp W=230e-9 L=60e-9 MR=1
MNM5 net38 S1N net30 VPW nm1p2_svt_lp W=230e-9 L=60e-9 MR=1
MNM4 net30 S0 net22 VPW nm1p2_svt_lp W=230e-9 L=60e-9 MR=1
MNM3 net30 S0N net24 VPW nm1p2_svt_lp W=230e-9 L=60e-9 MR=1
MNM2 net20 C VSS VPW nm1p2_svt_lp W=230e-9 L=60e-9 MR=1
MNM1 net22 B VSS VPW nm1p2_svt_lp W=230e-9 L=60e-9 MR=1
MNM0 net24 A VSS VPW nm1p2_svt_lp W=230e-9 L=60e-9 MR=1
MPM10 S1N S1 VDD VNW pm1p2_svt_lp W=300e-9 L=60e-9 MR=1
MPM9 S0N S0 VDD VNW pm1p2_svt_lp W=300e-9 L=60e-9 MR=1
MPM8 Y net42 VDD VNW pm1p2_svt_lp W=300e-9 L=60e-9 MR=1
MPM7 net42 net38 VDD VNW pm1p2_svt_lp W=300e-9 L=60e-9 MR=1
MPM6 net38 S1N net20 VNW pm1p2_svt_lp W=300e-9 L=60e-9 MR=1
MPM5 net38 S1 net30 VNW pm1p2_svt_lp W=300e-9 L=60e-9 MR=1
MPM4 net30 S0N net22 VNW pm1p2_svt_lp W=300e-9 L=60e-9 MR=1
MPM3 net30 S0 net24 VNW pm1p2_svt_lp W=300e-9 L=60e-9 MR=1
MPM2 net20 C VDD VNW pm1p2_svt_lp W=300e-9 L=60e-9 MR=1
MPM1 net22 B VDD VNW pm1p2_svt_lp W=300e-9 L=60e-9 MR=1
MPM0 net24 A VDD VNW pm1p2_svt_lp W=300e-9 L=60e-9 MR=1
.ENDS
.SUBCKT MXI3X1_9TSVT A B C S0 S1 VDD VSS Y VNW VPW
MNM10 S1N S1 VSS VPW nm1p2_svt_lp W=230e-9 L=60e-9 MR=1
MNM9 S0N S0 VSS VPW nm1p2_svt_lp W=230e-9 L=60e-9 MR=1
MNM8 Y net42 VSS VPW nm1p2_svt_lp W=470e-9 L=60e-9 MR=1
MNM7 net42 net38 VSS VPW nm1p2_svt_lp W=470e-9 L=60e-9 MR=1
MNM6 net38 S1 net20 VPW nm1p2_svt_lp W=230n L=60n MR=1
MNM5 net38 S1N net30 VPW nm1p2_svt_lp W=230n L=60n MR=1
MNM4 net30 S0 net22 VPW nm1p2_svt_lp W=230n L=60n MR=1
MNM3 net30 S0N net24 VPW nm1p2_svt_lp W=230n L=60n MR=1
MNM2 net20 C VSS VPW nm1p2_svt_lp W=470e-9 L=60e-9 MR=1
MNM1 net22 B VSS VPW nm1p2_svt_lp W=470e-9 L=60e-9 MR=1
MNM0 net24 A VSS VPW nm1p2_svt_lp W=470e-9 L=60e-9 MR=1
MPM10 S1N S1 VDD VNW pm1p2_svt_lp W=300e-9 L=60e-9 MR=1
MPM9 S0N S0 VDD VNW pm1p2_svt_lp W=300e-9 L=60e-9 MR=1
MPM8 Y net42 VDD VNW pm1p2_svt_lp W=590e-9 L=60e-9 MR=1
MPM7 net42 net38 VDD VNW pm1p2_svt_lp W=590e-9 L=60e-9 MR=1
MPM6 net38 S1N net20 VNW pm1p2_svt_lp W=300n L=60n MR=1
MPM5 net38 S1 net30 VNW pm1p2_svt_lp W=300n L=60n MR=1
MPM4 net30 S0N net22 VNW pm1p2_svt_lp W=300n L=60n MR=1
MPM3 net30 S0 net24 VNW pm1p2_svt_lp W=300n L=60n MR=1
MPM2 net20 C VDD VNW pm1p2_svt_lp W=590e-9 L=60e-9 MR=1
MPM1 net22 B VDD VNW pm1p2_svt_lp W=590e-9 L=60e-9 MR=1
MPM0 net24 A VDD VNW pm1p2_svt_lp W=590e-9 L=60e-9 MR=1
.ENDS
.SUBCKT MXI3X2_9TSVT A B C S0 S1 VDD VSS Y VNW VPW
MNM10 S1N S1 VSS VPW nm1p2_svt_lp W=230e-9 L=60e-9 MR=1
MNM9 S0N S0 VSS VPW nm1p2_svt_lp W=230e-9 L=60e-9 MR=1
MNM8 Y net42 VSS VPW nm1p2_svt_lp W=940e-9 L=60e-9 MR=1
MNM7 net42 net38 VSS VPW nm1p2_svt_lp W=470e-9 L=60e-9 MR=1
MNM6 net38 S1 net20 VPW nm1p2_svt_lp W=470e-9 L=60e-9 MR=1
MNM5 net38 S1N net30 VPW nm1p2_svt_lp W=470e-9 L=60e-9 MR=1
MNM4 net30 S0 net22 VPW nm1p2_svt_lp W=470e-9 L=60e-9 MR=1
MNM3 net30 S0N net24 VPW nm1p2_svt_lp W=470e-9 L=60e-9 MR=1
MNM2 net20 C VSS VPW nm1p2_svt_lp W=470e-9 L=60e-9 MR=1
MNM1 net22 B VSS VPW nm1p2_svt_lp W=470e-9 L=60e-9 MR=1
MNM0 net24 A VSS VPW nm1p2_svt_lp W=470e-9 L=60e-9 MR=1
MPM10 S1N S1 VDD VNW pm1p2_svt_lp W=300e-9 L=60e-9 MR=1
MPM9 S0N S0 VDD VNW pm1p2_svt_lp W=300e-9 L=60e-9 MR=1
MPM8 Y net42 VDD VNW pm1p2_svt_lp W=1.18e-6 L=60e-9 MR=1
MPM7 net42 net38 VDD VNW pm1p2_svt_lp W=590e-9 L=60e-9 MR=1
MPM6 net38 S1N net20 VNW pm1p2_svt_lp W=590e-9 L=60e-9 MR=1
MPM5 net38 S1 net30 VNW pm1p2_svt_lp W=590e-9 L=60e-9 MR=1
MPM4 net30 S0N net22 VNW pm1p2_svt_lp W=590e-9 L=60e-9 MR=1
MPM3 net30 S0 net24 VNW pm1p2_svt_lp W=590e-9 L=60e-9 MR=1
MPM2 net20 C VDD VNW pm1p2_svt_lp W=590e-9 L=60e-9 MR=1
MPM1 net22 B VDD VNW pm1p2_svt_lp W=590e-9 L=60e-9 MR=1
MPM0 net24 A VDD VNW pm1p2_svt_lp W=590e-9 L=60e-9 MR=1
.ENDS
.SUBCKT MXI3X3_9TSVT A B C S0 S1 VDD VSS Y VNW VPW
MNM10 S1N S1 VSS VPW nm1p2_svt_lp W=230e-9 L=60e-9 MR=1
MNM9 S0N S0 VSS VPW nm1p2_svt_lp W=230e-9 L=60e-9 MR=1
MNM8 Y net42 VSS VPW nm1p2_svt_lp W=1.41e-6 L=60e-9 MR=1
MNM7 net42 net38 VSS VPW nm1p2_svt_lp W=470e-9 L=60e-9 MR=1
MNM6 net38 S1 net20 VPW nm1p2_svt_lp W=470e-9 L=60e-9 MR=1
MNM5 net38 S1N net30 VPW nm1p2_svt_lp W=470e-9 L=60e-9 MR=1
MNM4 net30 S0 net22 VPW nm1p2_svt_lp W=470e-9 L=60e-9 MR=1
MNM3 net30 S0N net24 VPW nm1p2_svt_lp W=470e-9 L=60e-9 MR=1
MNM2 net20 C VSS VPW nm1p2_svt_lp W=470e-9 L=60e-9 MR=1
MNM1 net22 B VSS VPW nm1p2_svt_lp W=470e-9 L=60e-9 MR=1
MNM0 net24 A VSS VPW nm1p2_svt_lp W=470e-9 L=60e-9 MR=1
MPM10 S1N S1 VDD VNW pm1p2_svt_lp W=300e-9 L=60e-9 MR=1
MPM9 S0N S0 VDD VNW pm1p2_svt_lp W=300e-9 L=60e-9 MR=1
MPM8 Y net42 VDD VNW pm1p2_svt_lp W=1.77e-6 L=60e-9 MR=1
MPM7 net42 net38 VDD VNW pm1p2_svt_lp W=590e-9 L=60e-9 MR=1
MPM6 net38 S1N net20 VNW pm1p2_svt_lp W=590e-9 L=60e-9 MR=1
MPM5 net38 S1 net30 VNW pm1p2_svt_lp W=590e-9 L=60e-9 MR=1
MPM4 net30 S0N net22 VNW pm1p2_svt_lp W=590e-9 L=60e-9 MR=1
MPM3 net30 S0 net24 VNW pm1p2_svt_lp W=590e-9 L=60e-9 MR=1
MPM2 net20 C VDD VNW pm1p2_svt_lp W=590e-9 L=60e-9 MR=1
MPM1 net22 B VDD VNW pm1p2_svt_lp W=590e-9 L=60e-9 MR=1
MPM0 net24 A VDD VNW pm1p2_svt_lp W=590e-9 L=60e-9 MR=1
.ENDS
.SUBCKT MXI3X4_9TSVT A B C S0 S1 VDD VSS Y VNW VPW
MNM10 S1N S1 VSS VPW nm1p2_svt_lp W=230e-9 L=60e-9 MR=1
MNM9 S0N S0 VSS VPW nm1p2_svt_lp W=230e-9 L=60e-9 MR=1
MNM8 Y net42 VSS VPW nm1p2_svt_lp W=1.88e-6 L=60e-9 MR=1
MNM7 net42 net38 VSS VPW nm1p2_svt_lp W=940e-9 L=60e-9 MR=1
MNM6 net38 S1 net20 VPW nm1p2_svt_lp W=470e-9 L=60e-9 MR=1
MNM5 net38 S1N net30 VPW nm1p2_svt_lp W=470e-9 L=60e-9 MR=1
MNM4 net30 S0 net22 VPW nm1p2_svt_lp W=470e-9 L=60e-9 MR=1
MNM3 net30 S0N net24 VPW nm1p2_svt_lp W=470e-9 L=60e-9 MR=1
MNM2 net20 C VSS VPW nm1p2_svt_lp W=470e-9 L=60e-9 MR=1
MNM1 net22 B VSS VPW nm1p2_svt_lp W=470e-9 L=60e-9 MR=1
MNM0 net24 A VSS VPW nm1p2_svt_lp W=470e-9 L=60e-9 MR=1
MPM10 S1N S1 VDD VNW pm1p2_svt_lp W=300e-9 L=60e-9 MR=1
MPM9 S0N S0 VDD VNW pm1p2_svt_lp W=300e-9 L=60e-9 MR=1
MPM8 Y net42 VDD VNW pm1p2_svt_lp W=2.36e-6 L=60e-9 MR=1
MPM7 net42 net38 VDD VNW pm1p2_svt_lp W=1.18e-6 L=60e-9 MR=1
MPM6 net38 S1N net20 VNW pm1p2_svt_lp W=590e-9 L=60e-9 MR=1
MPM5 net38 S1 net30 VNW pm1p2_svt_lp W=590e-9 L=60e-9 MR=1
MPM4 net30 S0N net22 VNW pm1p2_svt_lp W=590e-9 L=60e-9 MR=1
MPM3 net30 S0 net24 VNW pm1p2_svt_lp W=590e-9 L=60e-9 MR=1
MPM2 net20 C VDD VNW pm1p2_svt_lp W=590e-9 L=60e-9 MR=1
MPM1 net22 B VDD VNW pm1p2_svt_lp W=590e-9 L=60e-9 MR=1
MPM0 net24 A VDD VNW pm1p2_svt_lp W=590e-9 L=60e-9 MR=1
.ENDS
.SUBCKT MXI3X6_9TSVT A B C S0 S1 VDD VSS Y VNW VPW
MNM10 S1N S1 VSS VPW nm1p2_svt_lp W=230n L=60n MR=1
MNM9 S0N S0 VSS VPW nm1p2_svt_lp W=230n L=60n MR=1
MNM8 Y net42 VSS VPW nm1p2_svt_lp W=2.82e-6 L=60e-9 MR=1
MNM7 net42 net38 VSS VPW nm1p2_svt_lp W=940e-9 L=60e-9 MR=1
MNM6 net38 S1 net20 VPW nm1p2_svt_lp W=470e-9 L=60e-9 MR=1
MNM5 net38 S1N net30 VPW nm1p2_svt_lp W=470e-9 L=60e-9 MR=1
MNM4 net30 S0 net22 VPW nm1p2_svt_lp W=470e-9 L=60e-9 MR=1
MNM3 net30 S0N net24 VPW nm1p2_svt_lp W=470e-9 L=60e-9 MR=1
MNM2 net20 C VSS VPW nm1p2_svt_lp W=470e-9 L=60e-9 MR=1
MNM1 net22 B VSS VPW nm1p2_svt_lp W=470e-9 L=60e-9 MR=1
MNM0 net24 A VSS VPW nm1p2_svt_lp W=470e-9 L=60e-9 MR=1
MPM10 S1N S1 VDD VNW pm1p2_svt_lp W=300n L=60n MR=1
MPM9 S0N S0 VDD VNW pm1p2_svt_lp W=300n L=60n MR=1
MPM8 Y net42 VDD VNW pm1p2_svt_lp W=3.54e-6 L=60e-9 MR=1
MPM7 net42 net38 VDD VNW pm1p2_svt_lp W=1.18e-6 L=60e-9 MR=1
MPM6 net38 S1N net20 VNW pm1p2_svt_lp W=590e-9 L=60e-9 MR=1
MPM5 net38 S1 net30 VNW pm1p2_svt_lp W=590e-9 L=60e-9 MR=1
MPM4 net30 S0N net22 VNW pm1p2_svt_lp W=590e-9 L=60e-9 MR=1
MPM3 net30 S0 net24 VNW pm1p2_svt_lp W=590e-9 L=60e-9 MR=1
MPM2 net20 C VDD VNW pm1p2_svt_lp W=590e-9 L=60e-9 MR=1
MPM1 net22 B VDD VNW pm1p2_svt_lp W=590e-9 L=60e-9 MR=1
MPM0 net24 A VDD VNW pm1p2_svt_lp W=590e-9 L=60e-9 MR=1
.ENDS
.SUBCKT MXI3X8_9TSVT A B C S0 S1 VDD VSS Y VNW VPW
MNM10 S1N S1 VSS VPW nm1p2_svt_lp W=230n L=60n MR=1
MNM9 S0N S0 VSS VPW nm1p2_svt_lp W=230n L=60n MR=1
MNM8 Y net42 VSS VPW nm1p2_svt_lp W=3.76e-6 L=60e-9 MR=1
MNM7 net42 net38 VSS VPW nm1p2_svt_lp W=1.41e-6 L=60e-9 MR=1
MNM6 net38 S1 net20 VPW nm1p2_svt_lp W=470e-9 L=60e-9 MR=1
MNM5 net38 S1N net30 VPW nm1p2_svt_lp W=470e-9 L=60e-9 MR=1
MNM4 net30 S0 net22 VPW nm1p2_svt_lp W=470e-9 L=60e-9 MR=1
MNM3 net30 S0N net24 VPW nm1p2_svt_lp W=470e-9 L=60e-9 MR=1
MNM2 net20 C VSS VPW nm1p2_svt_lp W=470e-9 L=60e-9 MR=1
MNM1 net22 B VSS VPW nm1p2_svt_lp W=470e-9 L=60e-9 MR=1
MNM0 net24 A VSS VPW nm1p2_svt_lp W=470e-9 L=60e-9 MR=1
MPM10 S1N S1 VDD VNW pm1p2_svt_lp W=300n L=60n MR=1
MPM9 S0N S0 VDD VNW pm1p2_svt_lp W=300n L=60n MR=1
MPM8 Y net42 VDD VNW pm1p2_svt_lp W=4.72e-6 L=60e-9 MR=1
MPM7 net42 net38 VDD VNW pm1p2_svt_lp W=1.77e-6 L=60e-9 MR=1
MPM6 net38 S1N net20 VNW pm1p2_svt_lp W=590e-9 L=60e-9 MR=1
MPM5 net38 S1 net30 VNW pm1p2_svt_lp W=590e-9 L=60e-9 MR=1
MPM4 net30 S0N net22 VNW pm1p2_svt_lp W=590e-9 L=60e-9 MR=1
MPM3 net30 S0 net24 VNW pm1p2_svt_lp W=590e-9 L=60e-9 MR=1
MPM2 net20 C VDD VNW pm1p2_svt_lp W=590e-9 L=60e-9 MR=1
MPM1 net22 B VDD VNW pm1p2_svt_lp W=590e-9 L=60e-9 MR=1
MPM0 net24 A VDD VNW pm1p2_svt_lp W=590e-9 L=60e-9 MR=1
.ENDS
.SUBCKT MXI4X0P5_9TSVT A B C D S0 S1 VDD VSS Y VNW VPW
MNM13 S1N S1 VSS VPW nm1p2_svt_lp W=230e-9 L=60e-9 MR=1
MNM12 S0N S0 VSS VPW nm1p2_svt_lp W=230e-9 L=60e-9 MR=1
MNM11 Y net52 VSS VPW nm1p2_svt_lp W=230e-9 L=60e-9 MR=1
MNM10 net52 net48 VSS VPW nm1p2_svt_lp W=230e-9 L=60e-9 MR=1
MNM9 net48 S1 net40 VPW nm1p2_svt_lp W=230e-9 L=60e-9 MR=1
MNM8 net48 S1N net39 VPW nm1p2_svt_lp W=230e-9 L=60e-9 MR=1
MNM7 net40 S0 net23 VPW nm1p2_svt_lp W=230e-9 L=60e-9 MR=1
MNM6 net40 S0N net25 VPW nm1p2_svt_lp W=230e-9 L=60e-9 MR=1
MNM5 net39 S0 net27 VPW nm1p2_svt_lp W=230e-9 L=60e-9 MR=1
MNM4 net39 S0N net29 VPW nm1p2_svt_lp W=230e-9 L=60e-9 MR=1
MNM3 net23 D VSS VPW nm1p2_svt_lp W=230e-9 L=60e-9 MR=1
MNM2 net25 C VSS VPW nm1p2_svt_lp W=230e-9 L=60e-9 MR=1
MNM1 net27 B VSS VPW nm1p2_svt_lp W=230e-9 L=60e-9 MR=1
MNM0 net29 A VSS VPW nm1p2_svt_lp W=230e-9 L=60e-9 MR=1
MPM13 S1N S1 VDD VNW pm1p2_svt_lp W=300e-9 L=60e-9 MR=1
MPM12 S0N S0 VDD VNW pm1p2_svt_lp W=300e-9 L=60e-9 MR=1
MPM11 Y net52 VDD VNW pm1p2_svt_lp W=300e-9 L=60e-9 MR=1
MPM10 net52 net48 VDD VNW pm1p2_svt_lp W=300e-9 L=60e-9 MR=1
MPM9 net48 S1N net40 VNW pm1p2_svt_lp W=275e-9 L=60e-9 MR=1
MPM8 net48 S1 net39 VNW pm1p2_svt_lp W=300e-9 L=60e-9 MR=1
MPM7 net40 S0N net23 VNW pm1p2_svt_lp W=300e-9 L=60e-9 MR=1
MPM6 net40 S0 net25 VNW pm1p2_svt_lp W=300e-9 L=60e-9 MR=1
MPM5 net39 S0N net27 VNW pm1p2_svt_lp W=300e-9 L=60e-9 MR=1
MPM4 net39 S0 net29 VNW pm1p2_svt_lp W=300e-9 L=60e-9 MR=1
MPM3 net23 D VDD VNW pm1p2_svt_lp W=300e-9 L=60e-9 MR=1
MPM2 net25 C VDD VNW pm1p2_svt_lp W=300e-9 L=60e-9 MR=1
MPM1 net27 B VDD VNW pm1p2_svt_lp W=300e-9 L=60e-9 MR=1
MPM0 net29 A VDD VNW pm1p2_svt_lp W=300e-9 L=60e-9 MR=1
.ENDS
.SUBCKT MXI4X1_9TSVT A B C D S0 S1 VDD VSS Y VNW VPW
MNM13 S1N S1 VSS VPW nm1p2_svt_lp W=230e-9 L=60e-9 MR=1
MNM12 S0N S0 VSS VPW nm1p2_svt_lp W=230e-9 L=60e-9 MR=1
MNM11 Y net52 VSS VPW nm1p2_svt_lp W=470e-9 L=60e-9 MR=1
MNM10 net52 net48 VSS VPW nm1p2_svt_lp W=470e-9 L=60e-9 MR=1
MNM9 net48 S1 net40 VPW nm1p2_svt_lp W=230n L=60n MR=1
MNM8 net48 S1N net39 VPW nm1p2_svt_lp W=230n L=60n MR=1
MNM7 net40 S0 net23 VPW nm1p2_svt_lp W=230n L=60n MR=1
MNM6 net40 S0N net25 VPW nm1p2_svt_lp W=230n L=60n MR=1
MNM5 net39 S0 net27 VPW nm1p2_svt_lp W=230n L=60n MR=1
MNM4 net39 S0N net29 VPW nm1p2_svt_lp W=230n L=60n MR=1
MNM3 net23 D VSS VPW nm1p2_svt_lp W=470e-9 L=60e-9 MR=1
MNM2 net25 C VSS VPW nm1p2_svt_lp W=470e-9 L=60e-9 MR=1
MNM1 net27 B VSS VPW nm1p2_svt_lp W=470e-9 L=60e-9 MR=1
MNM0 net29 A VSS VPW nm1p2_svt_lp W=470e-9 L=60e-9 MR=1
MPM13 S1N S1 VDD VNW pm1p2_svt_lp W=300e-9 L=60e-9 MR=1
MPM12 S0N S0 VDD VNW pm1p2_svt_lp W=300e-9 L=60e-9 MR=1
MPM11 Y net52 VDD VNW pm1p2_svt_lp W=590e-9 L=60e-9 MR=1
MPM10 net52 net48 VDD VNW pm1p2_svt_lp W=590e-9 L=60e-9 MR=1
MPM9 net48 S1N net40 VNW pm1p2_svt_lp W=300n L=60n MR=1
MPM8 net48 S1 net39 VNW pm1p2_svt_lp W=300n L=60n MR=1
MPM7 net40 S0N net23 VNW pm1p2_svt_lp W=300n L=60n MR=1
MPM6 net40 S0 net25 VNW pm1p2_svt_lp W=300n L=60n MR=1
MPM5 net39 S0N net27 VNW pm1p2_svt_lp W=300n L=60n MR=1
MPM4 net39 S0 net29 VNW pm1p2_svt_lp W=300n L=60n MR=1
MPM3 net23 D VDD VNW pm1p2_svt_lp W=410e-9 L=60e-9 MR=1
MPM2 net25 C VDD VNW pm1p2_svt_lp W=590e-9 L=60e-9 MR=1
MPM1 net27 B VDD VNW pm1p2_svt_lp W=410e-9 L=60e-9 MR=1
MPM0 net29 A VDD VNW pm1p2_svt_lp W=590e-9 L=60e-9 MR=1
.ENDS
.SUBCKT MXI4X2_9TSVT A B C D S0 S1 VDD VSS Y VNW VPW
MNM13 S1N S1 VSS VPW nm1p2_svt_lp W=230e-9 L=60e-9 MR=1
MNM12 S0N S0 VSS VPW nm1p2_svt_lp W=230e-9 L=60e-9 MR=1
MNM11 Y net52 VSS VPW nm1p2_svt_lp W=940e-9 L=60e-9 MR=1
MNM10 net52 net48 VSS VPW nm1p2_svt_lp W=470e-9 L=60e-9 MR=1
MNM9 net48 S1 net40 VPW nm1p2_svt_lp W=470e-9 L=60e-9 MR=1
MNM8 net48 S1N net39 VPW nm1p2_svt_lp W=470e-9 L=60e-9 MR=1
MNM7 net40 S0 net23 VPW nm1p2_svt_lp W=470e-9 L=60e-9 MR=1
MNM6 net40 S0N net25 VPW nm1p2_svt_lp W=470e-9 L=60e-9 MR=1
MNM5 net39 S0 net27 VPW nm1p2_svt_lp W=470e-9 L=60e-9 MR=1
MNM4 net39 S0N net29 VPW nm1p2_svt_lp W=470e-9 L=60e-9 MR=1
MNM3 net23 D VSS VPW nm1p2_svt_lp W=470e-9 L=60e-9 MR=1
MNM2 net25 C VSS VPW nm1p2_svt_lp W=470e-9 L=60e-9 MR=1
MNM1 net27 B VSS VPW nm1p2_svt_lp W=470e-9 L=60e-9 MR=1
MNM0 net29 A VSS VPW nm1p2_svt_lp W=470e-9 L=60e-9 MR=1
MPM13 S1N S1 VDD VNW pm1p2_svt_lp W=300e-9 L=60e-9 MR=1
MPM12 S0N S0 VDD VNW pm1p2_svt_lp W=300e-9 L=60e-9 MR=1
MPM11 Y net52 VDD VNW pm1p2_svt_lp W=1.18e-6 L=60e-9 MR=1
MPM10 net52 net48 VDD VNW pm1p2_svt_lp W=590e-9 L=60e-9 MR=1
MPM9 net48 S1N net40 VNW pm1p2_svt_lp W=470e-9 L=60e-9 MR=1
MPM8 net48 S1 net39 VNW pm1p2_svt_lp W=590e-9 L=60e-9 MR=1
MPM7 net40 S0N net23 VNW pm1p2_svt_lp W=590e-9 L=60e-9 MR=1
MPM6 net40 S0 net25 VNW pm1p2_svt_lp W=590e-9 L=60e-9 MR=1
MPM5 net39 S0N net27 VNW pm1p2_svt_lp W=590e-9 L=60e-9 MR=1
MPM4 net39 S0 net29 VNW pm1p2_svt_lp W=590e-9 L=60e-9 MR=1
MPM3 net23 D VDD VNW pm1p2_svt_lp W=410e-9 L=60e-9 MR=1
MPM2 net25 C VDD VNW pm1p2_svt_lp W=590e-9 L=60e-9 MR=1
MPM1 net27 B VDD VNW pm1p2_svt_lp W=410e-9 L=60e-9 MR=1
MPM0 net29 A VDD VNW pm1p2_svt_lp W=590e-9 L=60e-9 MR=1
.ENDS
.SUBCKT MXI4X3_9TSVT A B C D S0 S1 VDD VSS Y VNW VPW
MNM13 S1N S1 VSS VPW nm1p2_svt_lp W=230e-9 L=60e-9 MR=1
MNM12 S0N S0 VSS VPW nm1p2_svt_lp W=230e-9 L=60e-9 MR=1
MNM11 Y net52 VSS VPW nm1p2_svt_lp W=1.41e-6 L=60e-9 MR=1
MNM10 net52 net48 VSS VPW nm1p2_svt_lp W=470e-9 L=60e-9 MR=1
MNM9 net48 S1 net40 VPW nm1p2_svt_lp W=470e-9 L=60e-9 MR=1
MNM8 net48 S1N net39 VPW nm1p2_svt_lp W=470e-9 L=60e-9 MR=1
MNM7 net40 S0 net23 VPW nm1p2_svt_lp W=470e-9 L=60e-9 MR=1
MNM6 net40 S0N net25 VPW nm1p2_svt_lp W=470e-9 L=60e-9 MR=1
MNM5 net39 S0 net27 VPW nm1p2_svt_lp W=470e-9 L=60e-9 MR=1
MNM4 net39 S0N net29 VPW nm1p2_svt_lp W=470e-9 L=60e-9 MR=1
MNM3 net23 D VSS VPW nm1p2_svt_lp W=470e-9 L=60e-9 MR=1
MNM2 net25 C VSS VPW nm1p2_svt_lp W=470e-9 L=60e-9 MR=1
MNM1 net27 B VSS VPW nm1p2_svt_lp W=470e-9 L=60e-9 MR=1
MNM0 net29 A VSS VPW nm1p2_svt_lp W=470e-9 L=60e-9 MR=1
MPM13 S1N S1 VDD VNW pm1p2_svt_lp W=300e-9 L=60e-9 MR=1
MPM12 S0N S0 VDD VNW pm1p2_svt_lp W=300e-9 L=60e-9 MR=1
MPM11 Y net52 VDD VNW pm1p2_svt_lp W=1.77e-6 L=60e-9 MR=1
MPM10 net52 net48 VDD VNW pm1p2_svt_lp W=590e-9 L=60e-9 MR=1
MPM9 net48 S1N net40 VNW pm1p2_svt_lp W=470e-9 L=60e-9 MR=1
MPM8 net48 S1 net39 VNW pm1p2_svt_lp W=590e-9 L=60e-9 MR=1
MPM7 net40 S0N net23 VNW pm1p2_svt_lp W=590e-9 L=60e-9 MR=1
MPM6 net40 S0 net25 VNW pm1p2_svt_lp W=590e-9 L=60e-9 MR=1
MPM5 net39 S0N net27 VNW pm1p2_svt_lp W=590e-9 L=60e-9 MR=1
MPM4 net39 S0 net29 VNW pm1p2_svt_lp W=590e-9 L=60e-9 MR=1
MPM3 net23 D VDD VNW pm1p2_svt_lp W=410e-9 L=60e-9 MR=1
MPM2 net25 C VDD VNW pm1p2_svt_lp W=590e-9 L=60e-9 MR=1
MPM1 net27 B VDD VNW pm1p2_svt_lp W=410e-9 L=60e-9 MR=1
MPM0 net29 A VDD VNW pm1p2_svt_lp W=590e-9 L=60e-9 MR=1
.ENDS
.SUBCKT MXI4X4_9TSVT A B C D S0 S1 VDD VSS Y VNW VPW
MNM13 S1N S1 VSS VPW nm1p2_svt_lp W=230e-9 L=60e-9 MR=1
MNM12 S0N S0 VSS VPW nm1p2_svt_lp W=230e-9 L=60e-9 MR=1
MNM11 Y net52 VSS VPW nm1p2_svt_lp W=1.88e-6 L=60e-9 MR=1
MNM10 net52 net48 VSS VPW nm1p2_svt_lp W=940e-9 L=60e-9 MR=1
MNM9 net48 S1 net40 VPW nm1p2_svt_lp W=470e-9 L=60e-9 MR=1
MNM8 net48 S1N net39 VPW nm1p2_svt_lp W=470e-9 L=60e-9 MR=1
MNM7 net40 S0 net23 VPW nm1p2_svt_lp W=470e-9 L=60e-9 MR=1
MNM6 net40 S0N net25 VPW nm1p2_svt_lp W=470e-9 L=60e-9 MR=1
MNM5 net39 S0 net27 VPW nm1p2_svt_lp W=470e-9 L=60e-9 MR=1
MNM4 net39 S0N net29 VPW nm1p2_svt_lp W=470e-9 L=60e-9 MR=1
MNM3 net23 D VSS VPW nm1p2_svt_lp W=470e-9 L=60e-9 MR=1
MNM2 net25 C VSS VPW nm1p2_svt_lp W=470e-9 L=60e-9 MR=1
MNM1 net27 B VSS VPW nm1p2_svt_lp W=470e-9 L=60e-9 MR=1
MNM0 net29 A VSS VPW nm1p2_svt_lp W=470e-9 L=60e-9 MR=1
MPM13 S1N S1 VDD VNW pm1p2_svt_lp W=300e-9 L=60e-9 MR=1
MPM12 S0N S0 VDD VNW pm1p2_svt_lp W=300e-9 L=60e-9 MR=1
MPM11 Y net52 VDD VNW pm1p2_svt_lp W=2.36e-6 L=60e-9 MR=1
MPM10 net52 net48 VDD VNW pm1p2_svt_lp W=1.18e-6 L=60e-9 MR=1
MPM9 net48 S1N net40 VNW pm1p2_svt_lp W=470e-9 L=60e-9 MR=1
MPM8 net48 S1 net39 VNW pm1p2_svt_lp W=590e-9 L=60e-9 MR=1
MPM7 net40 S0N net23 VNW pm1p2_svt_lp W=590e-9 L=60e-9 MR=1
MPM6 net40 S0 net25 VNW pm1p2_svt_lp W=590e-9 L=60e-9 MR=1
MPM5 net39 S0N net27 VNW pm1p2_svt_lp W=590e-9 L=60e-9 MR=1
MPM4 net39 S0 net29 VNW pm1p2_svt_lp W=590e-9 L=60e-9 MR=1
MPM3 net23 D VDD VNW pm1p2_svt_lp W=410e-9 L=60e-9 MR=1
MPM2 net25 C VDD VNW pm1p2_svt_lp W=590e-9 L=60e-9 MR=1
MPM1 net27 B VDD VNW pm1p2_svt_lp W=410e-9 L=60e-9 MR=1
MPM0 net29 A VDD VNW pm1p2_svt_lp W=590e-9 L=60e-9 MR=1
.ENDS
.SUBCKT MXI4X6_9TSVT A B C D S0 S1 VDD VSS Y VNW VPW
MNM13 S1N S1 VSS VPW nm1p2_svt_lp W=230n L=60n MR=1
MNM12 S0N S0 VSS VPW nm1p2_svt_lp W=230n L=60n MR=1
MNM11 Y net52 VSS VPW nm1p2_svt_lp W=2.82e-6 L=60e-9 MR=1
MNM10 net52 net48 VSS VPW nm1p2_svt_lp W=940e-9 L=60e-9 MR=1
MNM9 net48 S1 net40 VPW nm1p2_svt_lp W=470e-9 L=60e-9 MR=1
MNM8 net48 S1N net39 VPW nm1p2_svt_lp W=470e-9 L=60e-9 MR=1
MNM7 net40 S0 net23 VPW nm1p2_svt_lp W=470e-9 L=60e-9 MR=1
MNM6 net40 S0N net25 VPW nm1p2_svt_lp W=470e-9 L=60e-9 MR=1
MNM5 net39 S0 net27 VPW nm1p2_svt_lp W=470e-9 L=60e-9 MR=1
MNM4 net39 S0N net29 VPW nm1p2_svt_lp W=470e-9 L=60e-9 MR=1
MNM3 net23 D VSS VPW nm1p2_svt_lp W=470e-9 L=60e-9 MR=1
MNM2 net25 C VSS VPW nm1p2_svt_lp W=470e-9 L=60e-9 MR=1
MNM1 net27 B VSS VPW nm1p2_svt_lp W=470e-9 L=60e-9 MR=1
MNM0 net29 A VSS VPW nm1p2_svt_lp W=470e-9 L=60e-9 MR=1
MPM13 S1N S1 VDD VNW pm1p2_svt_lp W=300n L=60n MR=1
MPM12 S0N S0 VDD VNW pm1p2_svt_lp W=300n L=60n MR=1
MPM11 Y net52 VDD VNW pm1p2_svt_lp W=3.54e-6 L=60e-9 MR=1
MPM10 net52 net48 VDD VNW pm1p2_svt_lp W=1.18e-6 L=60e-9 MR=1
MPM9 net48 S1N net40 VNW pm1p2_svt_lp W=470e-9 L=60e-9 MR=1
MPM8 net48 S1 net39 VNW pm1p2_svt_lp W=590e-9 L=60e-9 MR=1
MPM7 net40 S0N net23 VNW pm1p2_svt_lp W=590e-9 L=60e-9 MR=1
MPM6 net40 S0 net25 VNW pm1p2_svt_lp W=590e-9 L=60e-9 MR=1
MPM5 net39 S0N net27 VNW pm1p2_svt_lp W=590e-9 L=60e-9 MR=1
MPM4 net39 S0 net29 VNW pm1p2_svt_lp W=590e-9 L=60e-9 MR=1
MPM3 net23 D VDD VNW pm1p2_svt_lp W=410e-9 L=60e-9 MR=1
MPM2 net25 C VDD VNW pm1p2_svt_lp W=590e-9 L=60e-9 MR=1
MPM1 net27 B VDD VNW pm1p2_svt_lp W=380e-9 L=60e-9 MR=1
MPM0 net29 A VDD VNW pm1p2_svt_lp W=590e-9 L=60e-9 MR=1
.ENDS
.SUBCKT MXI4X8_9TSVT A B C D S0 S1 VDD VSS Y VNW VPW
MNM13 S1N S1 VSS VPW nm1p2_svt_lp W=230n L=60n MR=1
MNM12 S0N S0 VSS VPW nm1p2_svt_lp W=230n L=60n MR=1
MNM11 Y net52 VSS VPW nm1p2_svt_lp W=3.76e-6 L=60e-9 MR=1
MNM10 net52 net48 VSS VPW nm1p2_svt_lp W=1.41e-6 L=60e-9 MR=1
MNM9 net48 S1 net40 VPW nm1p2_svt_lp W=470e-9 L=60e-9 MR=1
MNM8 net48 S1N net39 VPW nm1p2_svt_lp W=470e-9 L=60e-9 MR=1
MNM7 net40 S0 net23 VPW nm1p2_svt_lp W=470e-9 L=60e-9 MR=1
MNM6 net40 S0N net25 VPW nm1p2_svt_lp W=470e-9 L=60e-9 MR=1
MNM5 net39 S0 net27 VPW nm1p2_svt_lp W=470e-9 L=60e-9 MR=1
MNM4 net39 S0N net29 VPW nm1p2_svt_lp W=470e-9 L=60e-9 MR=1
MNM3 net23 D VSS VPW nm1p2_svt_lp W=470e-9 L=60e-9 MR=1
MNM2 net25 C VSS VPW nm1p2_svt_lp W=470e-9 L=60e-9 MR=1
MNM1 net27 B VSS VPW nm1p2_svt_lp W=470e-9 L=60e-9 MR=1
MNM0 net29 A VSS VPW nm1p2_svt_lp W=470e-9 L=60e-9 MR=1
MPM13 S1N S1 VDD VNW pm1p2_svt_lp W=300n L=60n MR=1
MPM12 S0N S0 VDD VNW pm1p2_svt_lp W=300n L=60n MR=1
MPM11 Y net52 VDD VNW pm1p2_svt_lp W=4.72e-6 L=60e-9 MR=1
MPM10 net52 net48 VDD VNW pm1p2_svt_lp W=1.77e-6 L=60e-9 MR=1
MPM9 net48 S1N net40 VNW pm1p2_svt_lp W=470e-9 L=60e-9 MR=1
MPM8 net48 S1 net39 VNW pm1p2_svt_lp W=590e-9 L=60e-9 MR=1
MPM7 net40 S0N net23 VNW pm1p2_svt_lp W=590e-9 L=60e-9 MR=1
MPM6 net40 S0 net25 VNW pm1p2_svt_lp W=590e-9 L=60e-9 MR=1
MPM5 net39 S0N net27 VNW pm1p2_svt_lp W=590e-9 L=60e-9 MR=1
MPM4 net39 S0 net29 VNW pm1p2_svt_lp W=590e-9 L=60e-9 MR=1
MPM3 net23 D VDD VNW pm1p2_svt_lp W=410e-9 L=60e-9 MR=1
MPM2 net25 C VDD VNW pm1p2_svt_lp W=590e-9 L=60e-9 MR=1
MPM1 net27 B VDD VNW pm1p2_svt_lp W=380e-9 L=60e-9 MR=1
MPM0 net29 A VDD VNW pm1p2_svt_lp W=590e-9 L=60e-9 MR=1
.ENDS
.SUBCKT NAND2BX0P5_9TSVT AN B VDD VSS Y VNW VPW
MNM2 net13 AN VSS VPW nm1p2_svt_lp W=230e-9 L=60e-9 MR=1
MNM1 net18 B VSS VPW nm1p2_svt_lp W=230e-9 L=60e-9 MR=1
MNM0 Y net13 net18 VPW nm1p2_svt_lp W=230e-9 L=60e-9 MR=1
MPM2 net13 AN VDD VNW pm1p2_svt_lp W=300e-9 L=60e-9 MR=1
MPM1 Y B VDD VNW pm1p2_svt_lp W=300e-9 L=60e-9 MR=1
MPM0 Y net13 VDD VNW pm1p2_svt_lp W=300e-9 L=60e-9 MR=1
.ENDS
.SUBCKT NAND2BX1_9TSVT AN B VDD VSS Y VNW VPW
MNM2 net13 AN VSS VPW nm1p2_svt_lp W=230e-9 L=60e-9 MR=1
MNM1 net18 B VSS VPW nm1p2_svt_lp W=470e-9 L=60e-9 MR=1
MNM0 Y net13 net18 VPW nm1p2_svt_lp W=470e-9 L=60e-9 MR=1
MPM2 net13 AN VDD VNW pm1p2_svt_lp W=300e-9 L=60e-9 MR=1
MPM1 Y B VDD VNW pm1p2_svt_lp W=590e-9 L=60e-9 MR=1
MPM0 Y net13 VDD VNW pm1p2_svt_lp W=590e-9 L=60e-9 MR=1
.ENDS
.SUBCKT NAND2BX2_9TSVT AN B VDD VSS Y VNW VPW
MNM2 net13 AN VSS VPW nm1p2_svt_lp W=470e-9 L=60e-9 MR=1
MNM1 net18 B VSS VPW nm1p2_svt_lp W=940e-9 L=60e-9 MR=1
MNM0 Y net13 net18 VPW nm1p2_svt_lp W=940e-9 L=60e-9 MR=1
MPM2 net13 AN VDD VNW pm1p2_svt_lp W=590e-9 L=60e-9 MR=1
MPM1 Y B VDD VNW pm1p2_svt_lp W=1.18e-6 L=60e-9 MR=1
MPM0 Y net13 VDD VNW pm1p2_svt_lp W=1.18e-6 L=60e-9 MR=1
.ENDS
.SUBCKT NAND2BX3_9TSVT AN B VDD VSS Y VNW VPW
MNM2 net13 AN VSS VPW nm1p2_svt_lp W=470e-9 L=60e-9 MR=1
MNM1 net18 B VSS VPW nm1p2_svt_lp W=1.41e-6 L=60e-9 MR=1
MNM0 Y net13 net18 VPW nm1p2_svt_lp W=1.41e-6 L=60e-9 MR=1
MPM2 net13 AN VDD VNW pm1p2_svt_lp W=590e-9 L=60e-9 MR=1
MPM1 Y B VDD VNW pm1p2_svt_lp W=1.77e-6 L=60e-9 MR=1
MPM0 Y net13 VDD VNW pm1p2_svt_lp W=1.77e-6 L=60e-9 MR=1
.ENDS
.SUBCKT NAND2BX4_9TSVT AN B VDD VSS Y VNW VPW
MNM2 net13 AN VSS VPW nm1p2_svt_lp W=940e-9 L=60e-9 MR=1
MNM1 net18 B VSS VPW nm1p2_svt_lp W=1.88e-6 L=60e-9 MR=1
MNM0 Y net13 net18 VPW nm1p2_svt_lp W=1.88e-6 L=60e-9 MR=1
MPM2 net13 AN VDD VNW pm1p2_svt_lp W=1.18e-6 L=60e-9 MR=1
MPM1 Y B VDD VNW pm1p2_svt_lp W=2.36e-6 L=60e-9 MR=1
MPM0 Y net13 VDD VNW pm1p2_svt_lp W=2.36e-6 L=60e-9 MR=1
.ENDS
.SUBCKT NAND2BX6_9TSVT AN B VDD VSS Y VNW VPW
MNM2 net13 AN VSS VPW nm1p2_svt_lp W=940e-9 L=60e-9 MR=1
MNM1 net18 B VSS VPW nm1p2_svt_lp W=2.82e-6 L=60e-9 MR=1
MNM0 Y net13 net18 VPW nm1p2_svt_lp W=2.82e-6 L=60e-9 MR=1
MPM2 net13 AN VDD VNW pm1p2_svt_lp W=1.18e-6 L=60e-9 MR=1
MPM1 Y B VDD VNW pm1p2_svt_lp W=3.54e-6 L=60e-9 MR=1
MPM0 Y net13 VDD VNW pm1p2_svt_lp W=3.54e-6 L=60e-9 MR=1
.ENDS
.SUBCKT NAND2BX8_9TSVT AN B VDD VSS Y VNW VPW
MNM2 net13 AN VSS VPW nm1p2_svt_lp W=1.41e-6 L=60e-9 MR=1
MNM1 net18 B VSS VPW nm1p2_svt_lp W=3.76e-6 L=60e-9 MR=1
MNM0 Y net13 net18 VPW nm1p2_svt_lp W=3.76e-6 L=60e-9 MR=1
MPM2 net13 AN VDD VNW pm1p2_svt_lp W=1.77e-6 L=60e-9 MR=1
MPM1 Y B VDD VNW pm1p2_svt_lp W=4.72e-6 L=60e-9 MR=1
MPM0 Y net13 VDD VNW pm1p2_svt_lp W=4.72e-6 L=60e-9 MR=1
.ENDS
.SUBCKT NAND2X0P5_9TSVT A B VDD VSS Y VNW VPW
MNM1 net15 B VSS VPW nm1p2_svt_lp W=230e-9 L=60e-9 MR=1
MNM0 Y A net15 VPW nm1p2_svt_lp W=230e-9 L=60e-9 MR=1
MPM1 Y B VDD VNW pm1p2_svt_lp W=300e-9 L=60e-9 MR=1
MPM0 Y A VDD VNW pm1p2_svt_lp W=300e-9 L=60e-9 MR=1
.ENDS
.SUBCKT NAND2X1_9TSVT A B VDD VSS Y VNW VPW
MNM1 net15 B VSS VPW nm1p2_svt_lp W=470e-9 L=60e-9 MR=1
MNM0 Y A net15 VPW nm1p2_svt_lp W=470e-9 L=60e-9 MR=1
MPM1 Y B VDD VNW pm1p2_svt_lp W=590e-9 L=60e-9 MR=1
MPM0 Y A VDD VNW pm1p2_svt_lp W=590e-9 L=60e-9 MR=1
.ENDS
.SUBCKT NAND2X2_9TSVT A B VDD VSS Y VNW VPW
MNM1 net15 B VSS VPW nm1p2_svt_lp W=940e-9 L=60e-9 MR=1
MNM0 Y A net15 VPW nm1p2_svt_lp W=940e-9 L=60e-9 MR=1
MPM1 Y B VDD VNW pm1p2_svt_lp W=1.18e-6 L=60e-9 MR=1
MPM0 Y A VDD VNW pm1p2_svt_lp W=1.18e-6 L=60e-9 MR=1
.ENDS
.SUBCKT NAND2X3_9TSVT A B VDD VSS Y VNW VPW
MNM1 net15 B VSS VPW nm1p2_svt_lp W=1.41e-6 L=60e-9 MR=1
MNM0 Y A net15 VPW nm1p2_svt_lp W=1.41e-6 L=60e-9 MR=1
MPM1 Y B VDD VNW pm1p2_svt_lp W=1.77e-6 L=60e-9 MR=1
MPM0 Y A VDD VNW pm1p2_svt_lp W=1.77e-6 L=60e-9 MR=1
.ENDS
.SUBCKT NAND2X4_9TSVT A B VDD VSS Y VNW VPW
MNM1 net15 B VSS VPW nm1p2_svt_lp W=1.88e-6 L=60e-9 MR=1
MNM0 Y A net15 VPW nm1p2_svt_lp W=1.88e-6 L=60e-9 MR=1
MPM1 Y B VDD VNW pm1p2_svt_lp W=2.36e-6 L=60e-9 MR=1
MPM0 Y A VDD VNW pm1p2_svt_lp W=2.36e-6 L=60e-9 MR=1
.ENDS
.SUBCKT NAND2X6_9TSVT A B VDD VSS Y VNW VPW
MNM1 net15 B VSS VPW nm1p2_svt_lp W=2.82e-6 L=60e-9 MR=1
MNM0 Y A net15 VPW nm1p2_svt_lp W=2.82e-6 L=60e-9 MR=1
MPM1 Y B VDD VNW pm1p2_svt_lp W=3.54e-6 L=60e-9 MR=1
MPM0 Y A VDD VNW pm1p2_svt_lp W=3.54e-6 L=60e-9 MR=1
.ENDS
.SUBCKT NAND2X8_9TSVT A B VDD VSS Y VNW VPW
MNM1 net15 B VSS VPW nm1p2_svt_lp W=3.76e-6 L=60e-9 MR=1
MNM0 Y A net15 VPW nm1p2_svt_lp W=3.76e-6 L=60e-9 MR=1
MPM1 Y B VDD VNW pm1p2_svt_lp W=4.72e-6 L=60e-9 MR=1
MPM0 Y A VDD VNW pm1p2_svt_lp W=4.72e-6 L=60e-9 MR=1
.ENDS
.SUBCKT NAND3BBX0P5_9TSVT AN BN C VDD VSS Y VNW VPW
MNM4 net19 BN VSS VPW nm1p2_svt_lp W=230e-9 L=60e-9 MR=1
MNM3 net18 AN VSS VPW nm1p2_svt_lp W=230e-9 L=60e-9 MR=1
MNM2 net27 C VSS VPW nm1p2_svt_lp W=230e-9 L=60e-9 MR=1
MNM1 net28 net19 net27 VPW nm1p2_svt_lp W=230e-9 L=60e-9 MR=1
MNM0 Y net18 net28 VPW nm1p2_svt_lp W=230e-9 L=60e-9 MR=1
MPM4 net19 BN VDD VNW pm1p2_svt_lp W=300e-9 L=60e-9 MR=1
MPM3 net18 AN VDD VNW pm1p2_svt_lp W=300e-9 L=60e-9 MR=1
MPM2 Y C VDD VNW pm1p2_svt_lp W=300e-9 L=60e-9 MR=1
MPM1 Y net19 VDD VNW pm1p2_svt_lp W=300e-9 L=60e-9 MR=1
MPM0 Y net18 VDD VNW pm1p2_svt_lp W=300e-9 L=60e-9 MR=1
.ENDS
.SUBCKT NAND3BBX1_9TSVT AN BN C VDD VSS Y VNW VPW
MNM4 net19 BN VSS VPW nm1p2_svt_lp W=230e-9 L=60e-9 MR=1
MNM3 net18 AN VSS VPW nm1p2_svt_lp W=230e-9 L=60e-9 MR=1
MNM2 net27 C VSS VPW nm1p2_svt_lp W=470e-9 L=60e-9 MR=1
MNM1 net28 net19 net27 VPW nm1p2_svt_lp W=470e-9 L=60e-9 MR=1
MNM0 Y net18 net28 VPW nm1p2_svt_lp W=470e-9 L=60e-9 MR=1
MPM4 net19 BN VDD VNW pm1p2_svt_lp W=300e-9 L=60e-9 MR=1
MPM3 net18 AN VDD VNW pm1p2_svt_lp W=300e-9 L=60e-9 MR=1
MPM2 Y C VDD VNW pm1p2_svt_lp W=590e-9 L=60e-9 MR=1
MPM1 Y net19 VDD VNW pm1p2_svt_lp W=590e-9 L=60e-9 MR=1
MPM0 Y net18 VDD VNW pm1p2_svt_lp W=590e-9 L=60e-9 MR=1
.ENDS
.SUBCKT NAND3BBX2_9TSVT AN BN C VDD VSS Y VNW VPW
MNM4 net19 BN VSS VPW nm1p2_svt_lp W=470e-9 L=60e-9 MR=1
MNM3 net18 AN VSS VPW nm1p2_svt_lp W=470e-9 L=60e-9 MR=1
MNM2 net27 C VSS VPW nm1p2_svt_lp W=940e-9 L=60e-9 MR=1
MNM1 net28 net19 net27 VPW nm1p2_svt_lp W=940e-9 L=60e-9 MR=1
MNM0 Y net18 net28 VPW nm1p2_svt_lp W=940e-9 L=60e-9 MR=1
MPM4 net19 BN VDD VNW pm1p2_svt_lp W=590e-9 L=60e-9 MR=1
MPM3 net18 AN VDD VNW pm1p2_svt_lp W=590e-9 L=60e-9 MR=1
MPM2 Y C VDD VNW pm1p2_svt_lp W=1.18e-6 L=60e-9 MR=1
MPM1 Y net19 VDD VNW pm1p2_svt_lp W=1.18e-6 L=60e-9 MR=1
MPM0 Y net18 VDD VNW pm1p2_svt_lp W=1.18e-6 L=60e-9 MR=1
.ENDS
.SUBCKT NAND3BBX3_9TSVT AN BN C VDD VSS Y VNW VPW
MNM4 net19 BN VSS VPW nm1p2_svt_lp W=470e-9 L=60e-9 MR=1
MNM3 net18 AN VSS VPW nm1p2_svt_lp W=470e-9 L=60e-9 MR=1
MNM2 net27 C VSS VPW nm1p2_svt_lp W=1.41e-6 L=60e-9 MR=1
MNM1 net28 net19 net27 VPW nm1p2_svt_lp W=1.41e-6 L=60e-9 MR=1
MNM0 Y net18 net28 VPW nm1p2_svt_lp W=1.41e-6 L=60e-9 MR=1
MPM4 net19 BN VDD VNW pm1p2_svt_lp W=590e-9 L=60e-9 MR=1
MPM3 net18 AN VDD VNW pm1p2_svt_lp W=590e-9 L=60e-9 MR=1
MPM2 Y C VDD VNW pm1p2_svt_lp W=1.77e-6 L=60e-9 MR=1
MPM1 Y net19 VDD VNW pm1p2_svt_lp W=1.77e-6 L=60e-9 MR=1
MPM0 Y net18 VDD VNW pm1p2_svt_lp W=1.77e-6 L=60e-9 MR=1
.ENDS
.SUBCKT NAND3BBX4_9TSVT AN BN C VDD VSS Y VNW VPW
MNM4 net19 BN VSS VPW nm1p2_svt_lp W=940e-9 L=60e-9 MR=1
MNM3 net18 AN VSS VPW nm1p2_svt_lp W=940e-9 L=60e-9 MR=1
MNM2 net27 C VSS VPW nm1p2_svt_lp W=1.88e-6 L=60e-9 MR=1
MNM1 net28 net19 net27 VPW nm1p2_svt_lp W=1.88e-6 L=60e-9 MR=1
MNM0 Y net18 net28 VPW nm1p2_svt_lp W=1.88e-6 L=60e-9 MR=1
MPM4 net19 BN VDD VNW pm1p2_svt_lp W=1.18e-6 L=60e-9 MR=1
MPM3 net18 AN VDD VNW pm1p2_svt_lp W=1.18e-6 L=60e-9 MR=1
MPM2 Y C VDD VNW pm1p2_svt_lp W=2.36e-6 L=60e-9 MR=1
MPM1 Y net19 VDD VNW pm1p2_svt_lp W=2.36e-6 L=60e-9 MR=1
MPM0 Y net18 VDD VNW pm1p2_svt_lp W=2.36e-6 L=60e-9 MR=1
.ENDS
.SUBCKT NAND3BBX6_9TSVT AN BN C VDD VSS Y VNW VPW
MNM4 net19 BN VSS VPW nm1p2_svt_lp W=940e-9 L=60e-9 MR=1
MNM3 net18 AN VSS VPW nm1p2_svt_lp W=940e-9 L=60e-9 MR=1
MNM2 net27 C VSS VPW nm1p2_svt_lp W=2.82e-6 L=60e-9 MR=1
MNM1 net28 net19 net27 VPW nm1p2_svt_lp W=2.82e-6 L=60e-9 MR=1
MNM0 Y net18 net28 VPW nm1p2_svt_lp W=2.82e-6 L=60e-9 MR=1
MPM4 net19 BN VDD VNW pm1p2_svt_lp W=1.18e-6 L=60e-9 MR=1
MPM3 net18 AN VDD VNW pm1p2_svt_lp W=1.18e-6 L=60e-9 MR=1
MPM2 Y C VDD VNW pm1p2_svt_lp W=3.54e-6 L=60e-9 MR=1
MPM1 Y net19 VDD VNW pm1p2_svt_lp W=3.54e-6 L=60e-9 MR=1
MPM0 Y net18 VDD VNW pm1p2_svt_lp W=3.54e-6 L=60e-9 MR=1
.ENDS
.SUBCKT NAND3BBX8_9TSVT AN BN C VDD VSS Y VNW VPW
MNM4 net19 BN VSS VPW nm1p2_svt_lp W=1.41e-6 L=60e-9 MR=1
MNM3 net18 AN VSS VPW nm1p2_svt_lp W=1.41e-6 L=60e-9 MR=1
MNM2 net27 C VSS VPW nm1p2_svt_lp W=3.76e-6 L=60e-9 MR=1
MNM1 net28 net19 net27 VPW nm1p2_svt_lp W=3.76e-6 L=60e-9 MR=1
MNM0 Y net18 net28 VPW nm1p2_svt_lp W=3.76e-6 L=60e-9 MR=1
MPM4 net19 BN VDD VNW pm1p2_svt_lp W=1.77e-6 L=60e-9 MR=1
MPM3 net18 AN VDD VNW pm1p2_svt_lp W=1.77e-6 L=60e-9 MR=1
MPM2 Y C VDD VNW pm1p2_svt_lp W=4.72e-6 L=60e-9 MR=1
MPM1 Y net19 VDD VNW pm1p2_svt_lp W=4.72e-6 L=60e-9 MR=1
MPM0 Y net18 VDD VNW pm1p2_svt_lp W=4.72e-6 L=60e-9 MR=1
.ENDS
.SUBCKT NAND3BX0P5_9TSVT AN B C VDD VSS Y VNW VPW
MNM3 net15 AN VSS VPW nm1p2_svt_lp W=230e-9 L=60e-9 MR=1
MNM2 net23 C VSS VPW nm1p2_svt_lp W=230e-9 L=60e-9 MR=1
MNM1 net24 B net23 VPW nm1p2_svt_lp W=230e-9 L=60e-9 MR=1
MNM0 Y net15 net24 VPW nm1p2_svt_lp W=230e-9 L=60e-9 MR=1
MPM3 net15 AN VDD VNW pm1p2_svt_lp W=300e-9 L=60e-9 MR=1
MPM2 Y C VDD VNW pm1p2_svt_lp W=300e-9 L=60e-9 MR=1
MPM1 Y B VDD VNW pm1p2_svt_lp W=300e-9 L=60e-9 MR=1
MPM0 Y net15 VDD VNW pm1p2_svt_lp W=300e-9 L=60e-9 MR=1
.ENDS
.SUBCKT NAND3BX1_9TSVT AN B C VDD VSS Y VNW VPW
MNM3 net15 AN VSS VPW nm1p2_svt_lp W=230e-9 L=60e-9 MR=1
MNM2 net23 C VSS VPW nm1p2_svt_lp W=470e-9 L=60e-9 MR=1
MNM1 net24 B net23 VPW nm1p2_svt_lp W=470e-9 L=60e-9 MR=1
MNM0 Y net15 net24 VPW nm1p2_svt_lp W=470e-9 L=60e-9 MR=1
MPM3 net15 AN VDD VNW pm1p2_svt_lp W=300e-9 L=60e-9 MR=1
MPM2 Y C VDD VNW pm1p2_svt_lp W=590e-9 L=60e-9 MR=1
MPM1 Y B VDD VNW pm1p2_svt_lp W=590e-9 L=60e-9 MR=1
MPM0 Y net15 VDD VNW pm1p2_svt_lp W=590e-9 L=60e-9 MR=1
.ENDS
.SUBCKT NAND3BX2_9TSVT AN B C VDD VSS Y VNW VPW
MNM3 net15 AN VSS VPW nm1p2_svt_lp W=470e-9 L=60e-9 MR=1
MNM2 net23 C VSS VPW nm1p2_svt_lp W=940e-9 L=60e-9 MR=1
MNM1 net24 B net23 VPW nm1p2_svt_lp W=940e-9 L=60e-9 MR=1
MNM0 Y net15 net24 VPW nm1p2_svt_lp W=940e-9 L=60e-9 MR=1
MPM3 net15 AN VDD VNW pm1p2_svt_lp W=590e-9 L=60e-9 MR=1
MPM2 Y C VDD VNW pm1p2_svt_lp W=1.18e-6 L=60e-9 MR=1
MPM1 Y B VDD VNW pm1p2_svt_lp W=1.18e-6 L=60e-9 MR=1
MPM0 Y net15 VDD VNW pm1p2_svt_lp W=1.18e-6 L=60e-9 MR=1
.ENDS
.SUBCKT NAND3BX3_9TSVT AN B C VDD VSS Y VNW VPW
MNM3 net15 AN VSS VPW nm1p2_svt_lp W=470e-9 L=60e-9 MR=1
MNM2 net23 C VSS VPW nm1p2_svt_lp W=1.41e-6 L=60e-9 MR=1
MNM1 net24 B net23 VPW nm1p2_svt_lp W=1.41e-6 L=60e-9 MR=1
MNM0 Y net15 net24 VPW nm1p2_svt_lp W=1.41e-6 L=60e-9 MR=1
MPM3 net15 AN VDD VNW pm1p2_svt_lp W=590e-9 L=60e-9 MR=1
MPM2 Y C VDD VNW pm1p2_svt_lp W=1.77e-6 L=60e-9 MR=1
MPM1 Y B VDD VNW pm1p2_svt_lp W=1.77e-6 L=60e-9 MR=1
MPM0 Y net15 VDD VNW pm1p2_svt_lp W=1.77e-6 L=60e-9 MR=1
.ENDS
.SUBCKT NAND3BX4_9TSVT AN B C VDD VSS Y VNW VPW
MNM3 net15 AN VSS VPW nm1p2_svt_lp W=940e-9 L=60e-9 MR=1
MNM2 net23 C VSS VPW nm1p2_svt_lp W=1.88e-6 L=60e-9 MR=1
MNM1 net24 B net23 VPW nm1p2_svt_lp W=1.88e-6 L=60e-9 MR=1
MNM0 Y net15 net24 VPW nm1p2_svt_lp W=1.88e-6 L=60e-9 MR=1
MPM3 net15 AN VDD VNW pm1p2_svt_lp W=1.18e-6 L=60e-9 MR=1
MPM2 Y C VDD VNW pm1p2_svt_lp W=2.36e-6 L=60e-9 MR=1
MPM1 Y B VDD VNW pm1p2_svt_lp W=2.36e-6 L=60e-9 MR=1
MPM0 Y net15 VDD VNW pm1p2_svt_lp W=2.36e-6 L=60e-9 MR=1
.ENDS
.SUBCKT NAND3BX6_9TSVT AN B C VDD VSS Y VNW VPW
MNM3 net15 AN VSS VPW nm1p2_svt_lp W=940e-9 L=60e-9 MR=1
MNM2 net23 C VSS VPW nm1p2_svt_lp W=2.82e-6 L=60e-9 MR=1
MNM1 net24 B net23 VPW nm1p2_svt_lp W=2.82e-6 L=60e-9 MR=1
MNM0 Y net15 net24 VPW nm1p2_svt_lp W=2.82e-6 L=60e-9 MR=1
MPM3 net15 AN VDD VNW pm1p2_svt_lp W=1.18e-6 L=60e-9 MR=1
MPM2 Y C VDD VNW pm1p2_svt_lp W=3.54e-6 L=60e-9 MR=1
MPM1 Y B VDD VNW pm1p2_svt_lp W=3.54e-6 L=60e-9 MR=1
MPM0 Y net15 VDD VNW pm1p2_svt_lp W=3.54e-6 L=60e-9 MR=1
.ENDS
.SUBCKT NAND3BX8_9TSVT AN B C VDD VSS Y VNW VPW
MNM3 net15 AN VSS VPW nm1p2_svt_lp W=1.41e-6 L=60e-9 MR=1
MNM2 net23 C VSS VPW nm1p2_svt_lp W=3.76e-6 L=60e-9 MR=1
MNM1 net24 B net23 VPW nm1p2_svt_lp W=3.76e-6 L=60e-9 MR=1
MNM0 Y net15 net24 VPW nm1p2_svt_lp W=3.76e-6 L=60e-9 MR=1
MPM3 net15 AN VDD VNW pm1p2_svt_lp W=1.77e-6 L=60e-9 MR=1
MPM2 Y C VDD VNW pm1p2_svt_lp W=4.72e-6 L=60e-9 MR=1
MPM1 Y B VDD VNW pm1p2_svt_lp W=4.72e-6 L=60e-9 MR=1
MPM0 Y net15 VDD VNW pm1p2_svt_lp W=4.72e-6 L=60e-9 MR=1
.ENDS
.SUBCKT NAND3X0P5_9TSVT A B C VDD VSS Y VNW VPW
MNM2 net20 C VSS VPW nm1p2_svt_lp W=230e-9 L=60e-9 MR=1
MNM1 net21 B net20 VPW nm1p2_svt_lp W=230e-9 L=60e-9 MR=1
MNM0 Y A net21 VPW nm1p2_svt_lp W=230e-9 L=60e-9 MR=1
MPM2 Y C VDD VNW pm1p2_svt_lp W=300e-9 L=60e-9 MR=1
MPM1 Y B VDD VNW pm1p2_svt_lp W=300e-9 L=60e-9 MR=1
MPM0 Y A VDD VNW pm1p2_svt_lp W=300e-9 L=60e-9 MR=1
.ENDS
.SUBCKT NAND3X1_9TSVT A B C VDD VSS Y VNW VPW
MNM2 net20 C VSS VPW nm1p2_svt_lp W=470e-9 L=60e-9 MR=1
MNM1 net21 B net20 VPW nm1p2_svt_lp W=470e-9 L=60e-9 MR=1
MNM0 Y A net21 VPW nm1p2_svt_lp W=470e-9 L=60e-9 MR=1
MPM2 Y C VDD VNW pm1p2_svt_lp W=590e-9 L=60e-9 MR=1
MPM1 Y B VDD VNW pm1p2_svt_lp W=590e-9 L=60e-9 MR=1
MPM0 Y A VDD VNW pm1p2_svt_lp W=590e-9 L=60e-9 MR=1
.ENDS
.SUBCKT NAND3X2_9TSVT A B C VDD VSS Y VNW VPW
MNM2 net20 C VSS VPW nm1p2_svt_lp W=940e-9 L=60e-9 MR=1
MNM1 net21 B net20 VPW nm1p2_svt_lp W=940e-9 L=60e-9 MR=1
MNM0 Y A net21 VPW nm1p2_svt_lp W=940e-9 L=60e-9 MR=1
MPM2 Y C VDD VNW pm1p2_svt_lp W=1.18e-6 L=60e-9 MR=1
MPM1 Y B VDD VNW pm1p2_svt_lp W=1.18e-6 L=60e-9 MR=1
MPM0 Y A VDD VNW pm1p2_svt_lp W=1.18e-6 L=60e-9 MR=1
.ENDS
.SUBCKT NAND3X3_9TSVT A B C VDD VSS Y VNW VPW
MNM2 net20 C VSS VPW nm1p2_svt_lp W=1.41e-6 L=60e-9 MR=1
MNM1 net21 B net20 VPW nm1p2_svt_lp W=1.41e-6 L=60e-9 MR=1
MNM0 Y A net21 VPW nm1p2_svt_lp W=1.41e-6 L=60e-9 MR=1
MPM2 Y C VDD VNW pm1p2_svt_lp W=1.77e-6 L=60e-9 MR=1
MPM1 Y B VDD VNW pm1p2_svt_lp W=1.77e-6 L=60e-9 MR=1
MPM0 Y A VDD VNW pm1p2_svt_lp W=1.77e-6 L=60e-9 MR=1
.ENDS
.SUBCKT NAND3X4_9TSVT A B C VDD VSS Y VNW VPW
MNM2 net20 C VSS VPW nm1p2_svt_lp W=1.88e-6 L=60e-9 MR=1
MNM1 net21 B net20 VPW nm1p2_svt_lp W=1.88e-6 L=60e-9 MR=1
MNM0 Y A net21 VPW nm1p2_svt_lp W=1.88e-6 L=60e-9 MR=1
MPM2 Y C VDD VNW pm1p2_svt_lp W=2.36e-6 L=60e-9 MR=1
MPM1 Y B VDD VNW pm1p2_svt_lp W=2.36e-6 L=60e-9 MR=1
MPM0 Y A VDD VNW pm1p2_svt_lp W=2.36e-6 L=60e-9 MR=1
.ENDS
.SUBCKT NAND3X6_9TSVT A B C VDD VSS Y VNW VPW
MNM2 net20 C VSS VPW nm1p2_svt_lp W=2.82e-6 L=60e-9 MR=1
MNM1 net21 B net20 VPW nm1p2_svt_lp W=2.82e-6 L=60e-9 MR=1
MNM0 Y A net21 VPW nm1p2_svt_lp W=2.82e-6 L=60e-9 MR=1
MPM2 Y C VDD VNW pm1p2_svt_lp W=3.54e-6 L=60e-9 MR=1
MPM1 Y B VDD VNW pm1p2_svt_lp W=3.54e-6 L=60e-9 MR=1
MPM0 Y A VDD VNW pm1p2_svt_lp W=3.54e-6 L=60e-9 MR=1
.ENDS
.SUBCKT NAND3X8_9TSVT A B C VDD VSS Y VNW VPW
MNM2 net20 C VSS VPW nm1p2_svt_lp W=3.76e-6 L=60e-9 MR=1
MNM1 net21 B net20 VPW nm1p2_svt_lp W=3.76e-6 L=60e-9 MR=1
MNM0 Y A net21 VPW nm1p2_svt_lp W=3.76e-6 L=60e-9 MR=1
MPM2 Y C VDD VNW pm1p2_svt_lp W=4.72e-6 L=60e-9 MR=1
MPM1 Y B VDD VNW pm1p2_svt_lp W=4.72e-6 L=60e-9 MR=1
MPM0 Y A VDD VNW pm1p2_svt_lp W=4.72e-6 L=60e-9 MR=1
.ENDS
.SUBCKT NAND4BBX0P5_9TSVT AN BN C D VDD VSS Y VNW VPW
MNM5 net21 BN VSS VPW nm1p2_svt_lp W=230e-9 L=60e-9 MR=1
MNM4 net20 AN VSS VPW nm1p2_svt_lp W=230e-9 L=60e-9 MR=1
MNM3 net30 D VSS VPW nm1p2_svt_lp W=230e-9 L=60e-9 MR=1
MNM2 net31 C net30 VPW nm1p2_svt_lp W=230e-9 L=60e-9 MR=1
MNM1 net32 net21 net31 VPW nm1p2_svt_lp W=230e-9 L=60e-9 MR=1
MNM0 Y net20 net32 VPW nm1p2_svt_lp W=230e-9 L=60e-9 MR=1
MPM5 net21 BN VDD VNW pm1p2_svt_lp W=300e-9 L=60e-9 MR=1
MPM4 net20 AN VDD VNW pm1p2_svt_lp W=300e-9 L=60e-9 MR=1
MPM3 Y D VDD VNW pm1p2_svt_lp W=300e-9 L=60e-9 MR=1
MPM2 Y C VDD VNW pm1p2_svt_lp W=300e-9 L=60e-9 MR=1
MPM1 Y net21 VDD VNW pm1p2_svt_lp W=300e-9 L=60e-9 MR=1
MPM0 Y net20 VDD VNW pm1p2_svt_lp W=300e-9 L=60e-9 MR=1
.ENDS
.SUBCKT NAND4BBX1_9TSVT AN BN C D VDD VSS Y VNW VPW
MNM5 net21 BN VSS VPW nm1p2_svt_lp W=230e-9 L=60e-9 MR=1
MNM4 net20 AN VSS VPW nm1p2_svt_lp W=230e-9 L=60e-9 MR=1
MNM3 net30 D VSS VPW nm1p2_svt_lp W=470e-9 L=60e-9 MR=1
MNM2 net31 C net30 VPW nm1p2_svt_lp W=470e-9 L=60e-9 MR=1
MNM1 net32 net21 net31 VPW nm1p2_svt_lp W=470e-9 L=60e-9 MR=1
MNM0 Y net20 net32 VPW nm1p2_svt_lp W=470e-9 L=60e-9 MR=1
MPM5 net21 BN VDD VNW pm1p2_svt_lp W=300e-9 L=60e-9 MR=1
MPM4 net20 AN VDD VNW pm1p2_svt_lp W=300e-9 L=60e-9 MR=1
MPM3 Y D VDD VNW pm1p2_svt_lp W=590e-9 L=60e-9 MR=1
MPM2 Y C VDD VNW pm1p2_svt_lp W=590e-9 L=60e-9 MR=1
MPM1 Y net21 VDD VNW pm1p2_svt_lp W=590e-9 L=60e-9 MR=1
MPM0 Y net20 VDD VNW pm1p2_svt_lp W=590e-9 L=60e-9 MR=1
.ENDS
.SUBCKT NAND4BBX2_9TSVT AN BN C D VDD VSS Y VNW VPW
MNM5 net21 BN VSS VPW nm1p2_svt_lp W=470e-9 L=60e-9 MR=1
MNM4 net20 AN VSS VPW nm1p2_svt_lp W=470e-9 L=60e-9 MR=1
MNM3 net30 D VSS VPW nm1p2_svt_lp W=940e-9 L=60e-9 MR=1
MNM2 net31 C net30 VPW nm1p2_svt_lp W=940e-9 L=60e-9 MR=1
MNM1 net32 net21 net31 VPW nm1p2_svt_lp W=940e-9 L=60e-9 MR=1
MNM0 Y net20 net32 VPW nm1p2_svt_lp W=940e-9 L=60e-9 MR=1
MPM5 net21 BN VDD VNW pm1p2_svt_lp W=590e-9 L=60e-9 MR=1
MPM4 net20 AN VDD VNW pm1p2_svt_lp W=590e-9 L=60e-9 MR=1
MPM3 Y D VDD VNW pm1p2_svt_lp W=1.18e-6 L=60e-9 MR=1
MPM2 Y C VDD VNW pm1p2_svt_lp W=1.18e-6 L=60e-9 MR=1
MPM1 Y net21 VDD VNW pm1p2_svt_lp W=1.18e-6 L=60e-9 MR=1
MPM0 Y net20 VDD VNW pm1p2_svt_lp W=1.18e-6 L=60e-9 MR=1
.ENDS
.SUBCKT NAND4BBX3_9TSVT AN BN C D VDD VSS Y VNW VPW
MNM5 net21 BN VSS VPW nm1p2_svt_lp W=470e-9 L=60e-9 MR=1
MNM4 net20 AN VSS VPW nm1p2_svt_lp W=470e-9 L=60e-9 MR=1
MNM3 net30 D VSS VPW nm1p2_svt_lp W=1.41e-6 L=60e-9 MR=1
MNM2 net31 C net30 VPW nm1p2_svt_lp W=1.41e-6 L=60e-9 MR=1
MNM1 net32 net21 net31 VPW nm1p2_svt_lp W=1.41e-6 L=60e-9 MR=1
MNM0 Y net20 net32 VPW nm1p2_svt_lp W=1.41e-6 L=60e-9 MR=1
MPM5 net21 BN VDD VNW pm1p2_svt_lp W=590e-9 L=60e-9 MR=1
MPM4 net20 AN VDD VNW pm1p2_svt_lp W=590e-9 L=60e-9 MR=1
MPM3 Y D VDD VNW pm1p2_svt_lp W=1.77e-6 L=60e-9 MR=1
MPM2 Y C VDD VNW pm1p2_svt_lp W=1.77e-6 L=60e-9 MR=1
MPM1 Y net21 VDD VNW pm1p2_svt_lp W=1.77e-6 L=60e-9 MR=1
MPM0 Y net20 VDD VNW pm1p2_svt_lp W=1.77e-6 L=60e-9 MR=1
.ENDS
.SUBCKT NAND4BBX4_9TSVT AN BN C D VDD VSS Y VNW VPW
MNM5 net21 BN VSS VPW nm1p2_svt_lp W=940e-9 L=60e-9 MR=1
MNM4 net20 AN VSS VPW nm1p2_svt_lp W=940e-9 L=60e-9 MR=1
MNM3 net30 D VSS VPW nm1p2_svt_lp W=1.88e-6 L=60e-9 MR=1
MNM2 net31 C net30 VPW nm1p2_svt_lp W=1.88e-6 L=60e-9 MR=1
MNM1 net32 net21 net31 VPW nm1p2_svt_lp W=1.88e-6 L=60e-9 MR=1
MNM0 Y net20 net32 VPW nm1p2_svt_lp W=1.88e-6 L=60e-9 MR=1
MPM5 net21 BN VDD VNW pm1p2_svt_lp W=1.18e-6 L=60e-9 MR=1
MPM4 net20 AN VDD VNW pm1p2_svt_lp W=1.18e-6 L=60e-9 MR=1
MPM3 Y D VDD VNW pm1p2_svt_lp W=2.36e-6 L=60e-9 MR=1
MPM2 Y C VDD VNW pm1p2_svt_lp W=2.36e-6 L=60e-9 MR=1
MPM1 Y net21 VDD VNW pm1p2_svt_lp W=2.36e-6 L=60e-9 MR=1
MPM0 Y net20 VDD VNW pm1p2_svt_lp W=2.36e-6 L=60e-9 MR=1
.ENDS
.SUBCKT NAND4BBX6_9TSVT AN BN C D VDD VSS Y VNW VPW
MM3 Y net022 VSS VPW nm1p2_svt_lp W=2.82u L=60n MR=1
MM0 net022 net019 VSS VPW nm1p2_svt_lp W=940n L=60n MR=1
MNM5 net21 BN VSS VPW nm1p2_svt_lp W=470n L=60n MR=1
MNM4 net20 AN VSS VPW nm1p2_svt_lp W=470n L=60n MR=1
MNM3 net30 D VSS VPW nm1p2_svt_lp W=470n L=60n MR=1
MNM2 net31 C net30 VPW nm1p2_svt_lp W=470n L=60n MR=1
MNM1 net32 net21 net31 VPW nm1p2_svt_lp W=470n L=60n MR=1
MNM0 net019 net20 net32 VPW nm1p2_svt_lp W=470n L=60n MR=1
MM2 Y net022 VDD VNW pm1p2_svt_lp W=3.54u L=60n MR=1
MM1 net022 net019 VDD VNW pm1p2_svt_lp W=1.18u L=60n MR=1
MPM5 net21 BN VDD VNW pm1p2_svt_lp W=590n L=60n MR=1
MPM4 net20 AN VDD VNW pm1p2_svt_lp W=590n L=60n MR=1
MPM3 net019 D VDD VNW pm1p2_svt_lp W=590n L=60n MR=1
MPM2 net019 C VDD VNW pm1p2_svt_lp W=590n L=60n MR=1
MPM1 net019 net21 VDD VNW pm1p2_svt_lp W=590n L=60n MR=1
MPM0 net019 net20 VDD VNW pm1p2_svt_lp W=590n L=60n MR=1
.ENDS
.SUBCKT NAND4BBX8_9TSVT AN BN C D VDD VSS Y VNW VPW
MM3 Y net022 VSS VPW nm1p2_svt_lp W=3.76u L=60n MR=1
MM0 net022 net019 VSS VPW nm1p2_svt_lp W=1.41u L=60n MR=1
MNM5 net21 BN VSS VPW nm1p2_svt_lp W=470n L=60n MR=1
MNM4 net20 AN VSS VPW nm1p2_svt_lp W=470n L=60n MR=1
MNM3 net30 D VSS VPW nm1p2_svt_lp W=470n L=60n MR=1
MNM2 net31 C net30 VPW nm1p2_svt_lp W=470n L=60n MR=1
MNM1 net32 net21 net31 VPW nm1p2_svt_lp W=470n L=60n MR=1
MNM0 net019 net20 net32 VPW nm1p2_svt_lp W=470n L=60n MR=1
MM2 Y net022 VDD VNW pm1p2_svt_lp W=4.72u L=60n MR=1
MM1 net022 net019 VDD VNW pm1p2_svt_lp W=1.77u L=60n MR=1
MPM5 net21 BN VDD VNW pm1p2_svt_lp W=590n L=60n MR=1
MPM4 net20 AN VDD VNW pm1p2_svt_lp W=590n L=60n MR=1
MPM3 net019 D VDD VNW pm1p2_svt_lp W=590n L=60n MR=1
MPM2 net019 C VDD VNW pm1p2_svt_lp W=590n L=60n MR=1
MPM1 net019 net21 VDD VNW pm1p2_svt_lp W=590n L=60n MR=1
MPM0 net019 net20 VDD VNW pm1p2_svt_lp W=590n L=60n MR=1
.ENDS
.SUBCKT NAND4BX0P5_9TSVT AN B C D VDD VSS Y VNW VPW
MNM4 net17 AN VSS VPW nm1p2_svt_lp W=230e-9 L=60e-9 MR=1
MNM3 net26 D VSS VPW nm1p2_svt_lp W=230e-9 L=60e-9 MR=1
MNM2 net27 C net26 VPW nm1p2_svt_lp W=230e-9 L=60e-9 MR=1
MNM1 net28 B net27 VPW nm1p2_svt_lp W=230e-9 L=60e-9 MR=1
MNM0 Y net17 net28 VPW nm1p2_svt_lp W=230e-9 L=60e-9 MR=1
MPM4 net17 AN VDD VNW pm1p2_svt_lp W=300e-9 L=60e-9 MR=1
MPM3 Y D VDD VNW pm1p2_svt_lp W=300e-9 L=60e-9 MR=1
MPM2 Y C VDD VNW pm1p2_svt_lp W=300e-9 L=60e-9 MR=1
MPM1 Y B VDD VNW pm1p2_svt_lp W=300e-9 L=60e-9 MR=1
MPM0 Y net17 VDD VNW pm1p2_svt_lp W=300e-9 L=60e-9 MR=1
.ENDS
.SUBCKT NAND4BX1_9TSVT AN B C D VDD VSS Y VNW VPW
MNM4 net17 AN VSS VPW nm1p2_svt_lp W=230e-9 L=60e-9 MR=1
MNM3 net26 D VSS VPW nm1p2_svt_lp W=470e-9 L=60e-9 MR=1
MNM2 net27 C net26 VPW nm1p2_svt_lp W=470e-9 L=60e-9 MR=1
MNM1 net28 B net27 VPW nm1p2_svt_lp W=470e-9 L=60e-9 MR=1
MNM0 Y net17 net28 VPW nm1p2_svt_lp W=470e-9 L=60e-9 MR=1
MPM4 net17 AN VDD VNW pm1p2_svt_lp W=300e-9 L=60e-9 MR=1
MPM3 Y D VDD VNW pm1p2_svt_lp W=590e-9 L=60e-9 MR=1
MPM2 Y C VDD VNW pm1p2_svt_lp W=590e-9 L=60e-9 MR=1
MPM1 Y B VDD VNW pm1p2_svt_lp W=590e-9 L=60e-9 MR=1
MPM0 Y net17 VDD VNW pm1p2_svt_lp W=590e-9 L=60e-9 MR=1
.ENDS
.SUBCKT NAND4BX2_9TSVT AN B C D VDD VSS Y VNW VPW
MNM4 net17 AN VSS VPW nm1p2_svt_lp W=470e-9 L=60e-9 MR=1
MNM3 net26 D VSS VPW nm1p2_svt_lp W=940e-9 L=60e-9 MR=1
MNM2 net27 C net26 VPW nm1p2_svt_lp W=940e-9 L=60e-9 MR=1
MNM1 net28 B net27 VPW nm1p2_svt_lp W=940e-9 L=60e-9 MR=1
MNM0 Y net17 net28 VPW nm1p2_svt_lp W=940e-9 L=60e-9 MR=1
MPM4 net17 AN VDD VNW pm1p2_svt_lp W=590e-9 L=60e-9 MR=1
MPM3 Y D VDD VNW pm1p2_svt_lp W=1.18e-6 L=60e-9 MR=1
MPM2 Y C VDD VNW pm1p2_svt_lp W=1.18e-6 L=60e-9 MR=1
MPM1 Y B VDD VNW pm1p2_svt_lp W=1.18e-6 L=60e-9 MR=1
MPM0 Y net17 VDD VNW pm1p2_svt_lp W=1.18e-6 L=60e-9 MR=1
.ENDS
.SUBCKT NAND4BX3_9TSVT AN B C D VDD VSS Y VNW VPW
MNM4 net17 AN VSS VPW nm1p2_svt_lp W=470e-9 L=60e-9 MR=1
MNM3 net26 D VSS VPW nm1p2_svt_lp W=1.41e-6 L=60e-9 MR=1
MNM2 net27 C net26 VPW nm1p2_svt_lp W=1.41e-6 L=60e-9 MR=1
MNM1 net28 B net27 VPW nm1p2_svt_lp W=1.41e-6 L=60e-9 MR=1
MNM0 Y net17 net28 VPW nm1p2_svt_lp W=1.41e-6 L=60e-9 MR=1
MPM4 net17 AN VDD VNW pm1p2_svt_lp W=590e-9 L=60e-9 MR=1
MPM3 Y D VDD VNW pm1p2_svt_lp W=1.77e-6 L=60e-9 MR=1
MPM2 Y C VDD VNW pm1p2_svt_lp W=1.77e-6 L=60e-9 MR=1
MPM1 Y B VDD VNW pm1p2_svt_lp W=1.77e-6 L=60e-9 MR=1
MPM0 Y net17 VDD VNW pm1p2_svt_lp W=1.77e-6 L=60e-9 MR=1
.ENDS
.SUBCKT NAND4BX4_9TSVT AN B C D VDD VSS Y VNW VPW
MNM4 net17 AN VSS VPW nm1p2_svt_lp W=940e-9 L=60e-9 MR=1
MNM3 net26 D VSS VPW nm1p2_svt_lp W=1.88e-6 L=60e-9 MR=1
MNM2 net27 C net26 VPW nm1p2_svt_lp W=1.88e-6 L=60e-9 MR=1
MNM1 net28 B net27 VPW nm1p2_svt_lp W=1.88e-6 L=60e-9 MR=1
MNM0 Y net17 net28 VPW nm1p2_svt_lp W=1.88e-6 L=60e-9 MR=1
MPM4 net17 AN VDD VNW pm1p2_svt_lp W=1.18e-6 L=60e-9 MR=1
MPM3 Y D VDD VNW pm1p2_svt_lp W=2.36e-6 L=60e-9 MR=1
MPM2 Y C VDD VNW pm1p2_svt_lp W=2.36e-6 L=60e-9 MR=1
MPM1 Y B VDD VNW pm1p2_svt_lp W=2.36e-6 L=60e-9 MR=1
MPM0 Y net17 VDD VNW pm1p2_svt_lp W=2.36e-6 L=60e-9 MR=1
.ENDS
.SUBCKT NAND4BX6_9TSVT AN B C D VDD VSS Y VNW VPW
MM2 Y net018 VSS VPW nm1p2_svt_lp W=2.82u L=60n MR=1
MM0 net018 net015 VSS VPW nm1p2_svt_lp W=940n L=60n MR=1
MNM4 net17 AN VSS VPW nm1p2_svt_lp W=470n L=60n MR=1
MNM3 net26 D VSS VPW nm1p2_svt_lp W=470n L=60n MR=1
MNM2 net27 C net26 VPW nm1p2_svt_lp W=470n L=60n MR=1
MNM1 net28 B net27 VPW nm1p2_svt_lp W=470n L=60n MR=1
MNM0 net015 net17 net28 VPW nm1p2_svt_lp W=470n L=60n MR=1
MM3 Y net018 VDD VNW pm1p2_svt_lp W=3.54u L=60n MR=1
MM1 net018 net015 VDD VNW pm1p2_svt_lp W=1.18u L=60n MR=1
MPM4 net17 AN VDD VNW pm1p2_svt_lp W=590n L=60n MR=1
MPM3 net015 D VDD VNW pm1p2_svt_lp W=590n L=60n MR=1
MPM2 net015 C VDD VNW pm1p2_svt_lp W=590n L=60n MR=1
MPM1 net015 B VDD VNW pm1p2_svt_lp W=590n L=60n MR=1
MPM0 net015 net17 VDD VNW pm1p2_svt_lp W=590n L=60n MR=1
.ENDS
.SUBCKT NAND4BX8_9TSVT AN B C D VDD VSS Y VNW VPW
MM2 Y net018 VSS VPW nm1p2_svt_lp W=3.76u L=60n MR=1
MM0 net018 net015 VSS VPW nm1p2_svt_lp W=1.41u L=60n MR=1
MNM4 net17 AN VSS VPW nm1p2_svt_lp W=470n L=60n MR=1
MNM3 net26 D VSS VPW nm1p2_svt_lp W=470n L=60n MR=1
MNM2 net27 C net26 VPW nm1p2_svt_lp W=470n L=60n MR=1
MNM1 net28 B net27 VPW nm1p2_svt_lp W=470n L=60n MR=1
MNM0 net015 net17 net28 VPW nm1p2_svt_lp W=470n L=60n MR=1
MM3 Y net018 VDD VNW pm1p2_svt_lp W=4.72u L=60n MR=1
MM1 net018 net015 VDD VNW pm1p2_svt_lp W=1.77u L=60n MR=1
MPM4 net17 AN VDD VNW pm1p2_svt_lp W=590n L=60n MR=1
MPM3 net015 D VDD VNW pm1p2_svt_lp W=590n L=60n MR=1
MPM2 net015 C VDD VNW pm1p2_svt_lp W=590n L=60n MR=1
MPM1 net015 B VDD VNW pm1p2_svt_lp W=590n L=60n MR=1
MPM0 net015 net17 VDD VNW pm1p2_svt_lp W=590n L=60n MR=1
.ENDS
.SUBCKT NAND4X0P5_9TSVT A B C D VDD VSS Y VNW VPW
MNM3 net23 D VSS VPW nm1p2_svt_lp W=230e-9 L=60e-9 MR=1
MNM2 net24 C net23 VPW nm1p2_svt_lp W=230e-9 L=60e-9 MR=1
MNM1 net25 B net24 VPW nm1p2_svt_lp W=230e-9 L=60e-9 MR=1
MNM0 Y A net25 VPW nm1p2_svt_lp W=230e-9 L=60e-9 MR=1
MPM3 Y D VDD VNW pm1p2_svt_lp W=300e-9 L=60e-9 MR=1
MPM2 Y C VDD VNW pm1p2_svt_lp W=300e-9 L=60e-9 MR=1
MPM1 Y B VDD VNW pm1p2_svt_lp W=300e-9 L=60e-9 MR=1
MPM0 Y A VDD VNW pm1p2_svt_lp W=300e-9 L=60e-9 MR=1
.ENDS
.SUBCKT NAND4X1_9TSVT A B C D VDD VSS Y VNW VPW
MNM3 net23 D VSS VPW nm1p2_svt_lp W=470e-9 L=60e-9 MR=1
MNM2 net24 C net23 VPW nm1p2_svt_lp W=470e-9 L=60e-9 MR=1
MNM1 net25 B net24 VPW nm1p2_svt_lp W=470e-9 L=60e-9 MR=1
MNM0 Y A net25 VPW nm1p2_svt_lp W=470e-9 L=60e-9 MR=1
MPM3 Y D VDD VNW pm1p2_svt_lp W=590e-9 L=60e-9 MR=1
MPM2 Y C VDD VNW pm1p2_svt_lp W=590e-9 L=60e-9 MR=1
MPM1 Y B VDD VNW pm1p2_svt_lp W=590e-9 L=60e-9 MR=1
MPM0 Y A VDD VNW pm1p2_svt_lp W=590e-9 L=60e-9 MR=1
.ENDS
.SUBCKT NAND4X2_9TSVT A B C D VDD VSS Y VNW VPW
MNM3 net23 D VSS VPW nm1p2_svt_lp W=940e-9 L=60e-9 MR=1
MNM2 net24 C net23 VPW nm1p2_svt_lp W=940e-9 L=60e-9 MR=1
MNM1 net25 B net24 VPW nm1p2_svt_lp W=940e-9 L=60e-9 MR=1
MNM0 Y A net25 VPW nm1p2_svt_lp W=940e-9 L=60e-9 MR=1
MPM3 Y D VDD VNW pm1p2_svt_lp W=1.18e-6 L=60e-9 MR=1
MPM2 Y C VDD VNW pm1p2_svt_lp W=1.18e-6 L=60e-9 MR=1
MPM1 Y B VDD VNW pm1p2_svt_lp W=1.18e-6 L=60e-9 MR=1
MPM0 Y A VDD VNW pm1p2_svt_lp W=1.18e-6 L=60e-9 MR=1
.ENDS
.SUBCKT NAND4X3_9TSVT A B C D VDD VSS Y VNW VPW
MNM3 net23 D VSS VPW nm1p2_svt_lp W=1.41e-6 L=60e-9 MR=1
MNM2 net24 C net23 VPW nm1p2_svt_lp W=1.41e-6 L=60e-9 MR=1
MNM1 net25 B net24 VPW nm1p2_svt_lp W=1.41e-6 L=60e-9 MR=1
MNM0 Y A net25 VPW nm1p2_svt_lp W=1.41e-6 L=60e-9 MR=1
MPM3 Y D VDD VNW pm1p2_svt_lp W=1.77e-6 L=60e-9 MR=1
MPM2 Y C VDD VNW pm1p2_svt_lp W=1.77e-6 L=60e-9 MR=1
MPM1 Y B VDD VNW pm1p2_svt_lp W=1.77e-6 L=60e-9 MR=1
MPM0 Y A VDD VNW pm1p2_svt_lp W=1.77e-6 L=60e-9 MR=1
.ENDS
.SUBCKT NAND4X4_9TSVT A B C D VDD VSS Y VNW VPW
MNM3 net23 D VSS VPW nm1p2_svt_lp W=1.88e-6 L=60e-9 MR=1
MNM2 net24 C net23 VPW nm1p2_svt_lp W=1.88e-6 L=60e-9 MR=1
MNM1 net25 B net24 VPW nm1p2_svt_lp W=1.88e-6 L=60e-9 MR=1
MNM0 Y A net25 VPW nm1p2_svt_lp W=1.88e-6 L=60e-9 MR=1
MPM3 Y D VDD VNW pm1p2_svt_lp W=2.36e-6 L=60e-9 MR=1
MPM2 Y C VDD VNW pm1p2_svt_lp W=2.36e-6 L=60e-9 MR=1
MPM1 Y B VDD VNW pm1p2_svt_lp W=2.36e-6 L=60e-9 MR=1
MPM0 Y A VDD VNW pm1p2_svt_lp W=2.36e-6 L=60e-9 MR=1
.ENDS
.SUBCKT NAND4X6_9TSVT A B C D VDD VSS Y VNW VPW
MNM3 net23 D VSS VPW nm1p2_svt_lp W=470n L=60n MR=1
MNM2 net24 C net23 VPW nm1p2_svt_lp W=470n L=60n MR=1
MNM1 net25 B net24 VPW nm1p2_svt_lp W=470n L=60n MR=1
MNM0 net012 A net25 VPW nm1p2_svt_lp W=470n L=60n MR=1
MPM3 net012 D VDD VNW pm1p2_svt_lp W=590n L=60n MR=1
MPM2 net012 C VDD VNW pm1p2_svt_lp W=590n L=60n MR=1
MPM1 net012 B VDD VNW pm1p2_svt_lp W=590n L=60n MR=1
MPM0 net012 A VDD VNW pm1p2_svt_lp W=590n L=60n MR=1
MM3 Y net014 VSS VPW nm1p2_svt_lp W=2.82u L=60n MR=1
MM0 net014 net012 VSS VPW nm1p2_svt_lp W=940n L=60n MR=1
MM2 Y net014 VDD VNW pm1p2_svt_lp W=3.54u L=60n MR=1
MM1 net014 net012 VDD VNW pm1p2_svt_lp W=1.18u L=60n MR=1
.ENDS
.SUBCKT NAND4X8_9TSVT A B C D VDD VSS Y VNW VPW
MNM3 net23 D VSS VPW nm1p2_svt_lp W=470n L=60n MR=1
MNM2 net24 C net23 VPW nm1p2_svt_lp W=470n L=60n MR=1
MNM1 net25 B net24 VPW nm1p2_svt_lp W=470n L=60n MR=1
MNM0 net012 A net25 VPW nm1p2_svt_lp W=470n L=60n MR=1
MPM3 net012 D VDD VNW pm1p2_svt_lp W=590n L=60n MR=1
MPM2 net012 C VDD VNW pm1p2_svt_lp W=590n L=60n MR=1
MPM1 net012 B VDD VNW pm1p2_svt_lp W=590n L=60n MR=1
MPM0 net012 A VDD VNW pm1p2_svt_lp W=590n L=60n MR=1
MM2 Y net014 VSS VPW nm1p2_svt_lp W=3.76u L=60n MR=1
MM0 net014 net012 VSS VPW nm1p2_svt_lp W=1.41u L=60n MR=1
MM3 Y net014 VDD VNW pm1p2_svt_lp W=4.72u L=60n MR=1
MM1 net014 net012 VDD VNW pm1p2_svt_lp W=1.77u L=60n MR=1
.ENDS
.SUBCKT NOR2BX0P5_9TSVT AN B VDD VSS Y VNW VPW
MPM2 net13 AN VDD VNW pm1p2_svt_lp W=300e-9 L=60e-9 MR=1
MPM1 net19 B VDD VNW pm1p2_svt_lp W=300e-9 L=60e-9 MR=1
MPM0 Y net13 net19 VNW pm1p2_svt_lp W=300e-9 L=60e-9 MR=1
MNM2 net13 AN VSS VPW nm1p2_svt_lp W=230e-9 L=60e-9 MR=1
MNM1 Y B VSS VPW nm1p2_svt_lp W=230e-9 L=60e-9 MR=1
MNM0 Y net13 VSS VPW nm1p2_svt_lp W=230e-9 L=60e-9 MR=1
.ENDS
.SUBCKT NOR2BX1_9TSVT AN B VDD VSS Y VNW VPW
MPM2 net13 AN VDD VNW pm1p2_svt_lp W=300e-9 L=60e-9 MR=1
MPM1 net19 B VDD VNW pm1p2_svt_lp W=590e-9 L=60e-9 MR=1
MPM0 Y net13 net19 VNW pm1p2_svt_lp W=590e-9 L=60e-9 MR=1
MNM2 net13 AN VSS VPW nm1p2_svt_lp W=230e-9 L=60e-9 MR=1
MNM1 Y B VSS VPW nm1p2_svt_lp W=470e-9 L=60e-9 MR=1
MNM0 Y net13 VSS VPW nm1p2_svt_lp W=470e-9 L=60e-9 MR=1
.ENDS
.SUBCKT NOR2BX2_9TSVT AN B VDD VSS Y VNW VPW
MPM2 net13 AN VDD VNW pm1p2_svt_lp W=590e-9 L=60e-9 MR=1
MPM1 net19 B VDD VNW pm1p2_svt_lp W=1.18e-6 L=60e-9 MR=1
MPM0 Y net13 net19 VNW pm1p2_svt_lp W=1.18e-6 L=60e-9 MR=1
MNM2 net13 AN VSS VPW nm1p2_svt_lp W=470e-9 L=60e-9 MR=1
MNM1 Y B VSS VPW nm1p2_svt_lp W=940e-9 L=60e-9 MR=1
MNM0 Y net13 VSS VPW nm1p2_svt_lp W=940e-9 L=60e-9 MR=1
.ENDS
.SUBCKT NOR2BX3_9TSVT AN B VDD VSS Y VNW VPW
MPM2 net13 AN VDD VNW pm1p2_svt_lp W=590e-9 L=60e-9 MR=1
MPM1 net19 B VDD VNW pm1p2_svt_lp W=1.77e-6 L=60e-9 MR=1
MPM0 Y net13 net19 VNW pm1p2_svt_lp W=1.77e-6 L=60e-9 MR=1
MNM2 net13 AN VSS VPW nm1p2_svt_lp W=470e-9 L=60e-9 MR=1
MNM1 Y B VSS VPW nm1p2_svt_lp W=1.41e-6 L=60e-9 MR=1
MNM0 Y net13 VSS VPW nm1p2_svt_lp W=1.41e-6 L=60e-9 MR=1
.ENDS
.SUBCKT NOR2BX4_9TSVT AN B VDD VSS Y VNW VPW
MPM2 net13 AN VDD VNW pm1p2_svt_lp W=1.18e-6 L=60e-9 MR=1
MPM1 net19 B VDD VNW pm1p2_svt_lp W=2.36e-6 L=60e-9 MR=1
MPM0 Y net13 net19 VNW pm1p2_svt_lp W=2.36e-6 L=60e-9 MR=1
MNM2 net13 AN VSS VPW nm1p2_svt_lp W=940e-9 L=60e-9 MR=1
MNM1 Y B VSS VPW nm1p2_svt_lp W=1.88e-6 L=60e-9 MR=1
MNM0 Y net13 VSS VPW nm1p2_svt_lp W=1.88e-6 L=60e-9 MR=1
.ENDS
.SUBCKT NOR2BX6_9TSVT AN B VDD VSS Y VNW VPW
MPM2 net13 AN VDD VNW pm1p2_svt_lp W=1.18e-6 L=60e-9 MR=1
MPM1 net19 B VDD VNW pm1p2_svt_lp W=3.54e-6 L=60e-9 MR=1
MPM0 Y net13 net19 VNW pm1p2_svt_lp W=3.54e-6 L=60e-9 MR=1
MNM2 net13 AN VSS VPW nm1p2_svt_lp W=940e-9 L=60e-9 MR=1
MNM1 Y B VSS VPW nm1p2_svt_lp W=2.82e-6 L=60e-9 MR=1
MNM0 Y net13 VSS VPW nm1p2_svt_lp W=2.82e-6 L=60e-9 MR=1
.ENDS
.SUBCKT NOR2BX8_9TSVT AN B VDD VSS Y VNW VPW
MPM2 net13 AN VDD VNW pm1p2_svt_lp W=1.77e-6 L=60e-9 MR=1
MPM1 net19 B VDD VNW pm1p2_svt_lp W=4.72e-6 L=60e-9 MR=1
MPM0 Y net13 net19 VNW pm1p2_svt_lp W=4.72e-6 L=60e-9 MR=1
MNM2 net13 AN VSS VPW nm1p2_svt_lp W=1.41e-6 L=60e-9 MR=1
MNM1 Y B VSS VPW nm1p2_svt_lp W=3.76e-6 L=60e-9 MR=1
MNM0 Y net13 VSS VPW nm1p2_svt_lp W=3.76e-6 L=60e-9 MR=1
.ENDS
.SUBCKT NOR2X0P5_9TSVT A B VDD VSS Y VNW VPW
MPM1 net15 B VDD VNW pm1p2_svt_lp W=300e-9 L=60e-9 MR=1
MPM0 Y A net15 VNW pm1p2_svt_lp W=300e-9 L=60e-9 MR=1
MNM1 Y B VSS VPW nm1p2_svt_lp W=230e-9 L=60e-9 MR=1
MNM0 Y A VSS VPW nm1p2_svt_lp W=230e-9 L=60e-9 MR=1
.ENDS
.SUBCKT NOR2X1_9TSVT A B VDD VSS Y VNW VPW
MPM1 net15 B VDD VNW pm1p2_svt_lp W=590e-9 L=60e-9 MR=1
MPM0 Y A net15 VNW pm1p2_svt_lp W=590e-9 L=60e-9 MR=1
MNM1 Y B VSS VPW nm1p2_svt_lp W=470e-9 L=60e-9 MR=1
MNM0 Y A VSS VPW nm1p2_svt_lp W=470e-9 L=60e-9 MR=1
.ENDS
.SUBCKT NOR2X2_9TSVT A B VDD VSS Y VNW VPW
MPM1 net15 B VDD VNW pm1p2_svt_lp W=1.18e-6 L=60e-9 MR=1
MPM0 Y A net15 VNW pm1p2_svt_lp W=1.18e-6 L=60e-9 MR=1
MNM1 Y B VSS VPW nm1p2_svt_lp W=940e-9 L=60e-9 MR=1
MNM0 Y A VSS VPW nm1p2_svt_lp W=940e-9 L=60e-9 MR=1
.ENDS
.SUBCKT NOR2X3_9TSVT A B VDD VSS Y VNW VPW
MPM1 net15 B VDD VNW pm1p2_svt_lp W=1.77e-6 L=60e-9 MR=1
MPM0 Y A net15 VNW pm1p2_svt_lp W=1.77e-6 L=60e-9 MR=1
MNM1 Y B VSS VPW nm1p2_svt_lp W=1.41e-6 L=60e-9 MR=1
MNM0 Y A VSS VPW nm1p2_svt_lp W=1.41e-6 L=60e-9 MR=1
.ENDS
.SUBCKT NOR2X4_9TSVT A B VDD VSS Y VNW VPW
MPM1 net15 B VDD VNW pm1p2_svt_lp W=2.36e-6 L=60e-9 MR=1
MPM0 Y A net15 VNW pm1p2_svt_lp W=2.36e-6 L=60e-9 MR=1
MNM1 Y B VSS VPW nm1p2_svt_lp W=1.88e-6 L=60e-9 MR=1
MNM0 Y A VSS VPW nm1p2_svt_lp W=1.88e-6 L=60e-9 MR=1
.ENDS
.SUBCKT NOR2X6_9TSVT A B VDD VSS Y VNW VPW
MPM1 net15 B VDD VNW pm1p2_svt_lp W=3.54e-6 L=60e-9 MR=1
MPM0 Y A net15 VNW pm1p2_svt_lp W=3.54e-6 L=60e-9 MR=1
MNM1 Y B VSS VPW nm1p2_svt_lp W=2.82e-6 L=60e-9 MR=1
MNM0 Y A VSS VPW nm1p2_svt_lp W=2.82e-6 L=60e-9 MR=1
.ENDS
.SUBCKT NOR2X8_9TSVT A B VDD VSS Y VNW VPW
MPM1 net15 B VDD VNW pm1p2_svt_lp W=4.72e-6 L=60e-9 MR=1
MPM0 Y A net15 VNW pm1p2_svt_lp W=4.72e-6 L=60e-9 MR=1
MNM1 Y B VSS VPW nm1p2_svt_lp W=3.76e-6 L=60e-9 MR=1
MNM0 Y A VSS VPW nm1p2_svt_lp W=3.76e-6 L=60e-9 MR=1
.ENDS
.SUBCKT NOR3BBX0P5_9TSVT AN BN C VDD VSS Y VNW VPW
MPM4 net15 BN VDD VNW pm1p2_svt_lp W=300e-9 L=60e-9 MR=1
MPM3 net18 AN VDD VNW pm1p2_svt_lp W=300e-9 L=60e-9 MR=1
MPM2 net27 C VDD VNW pm1p2_svt_lp W=300e-9 L=60e-9 MR=1
MPM1 net28 net15 net27 VNW pm1p2_svt_lp W=300e-9 L=60e-9 MR=1
MPM0 Y net18 net28 VNW pm1p2_svt_lp W=300e-9 L=60e-9 MR=1
MNM4 net15 BN VSS VPW nm1p2_svt_lp W=150e-9 L=60e-9 MR=1
MNM3 net18 AN VSS VPW nm1p2_svt_lp W=150e-9 L=60e-9 MR=1
MNM2 Y C VSS VPW nm1p2_svt_lp W=150e-9 L=60e-9 MR=1
MNM1 Y net15 VSS VPW nm1p2_svt_lp W=150e-9 L=60e-9 MR=1
MNM0 Y net18 VSS VPW nm1p2_svt_lp W=150e-9 L=60e-9 MR=1
.ENDS
.SUBCKT NOR3BBX1_9TSVT AN BN C VDD VSS Y VNW VPW
MPM4 net15 BN VDD VNW pm1p2_svt_lp W=590e-9 L=60e-9 MR=1
MPM3 net18 AN VDD VNW pm1p2_svt_lp W=590e-9 L=60e-9 MR=1
MPM2 net27 C VDD VNW pm1p2_svt_lp W=590e-9 L=60e-9 MR=1
MPM1 net28 net15 net27 VNW pm1p2_svt_lp W=590e-9 L=60e-9 MR=1
MPM0 Y net18 net28 VNW pm1p2_svt_lp W=590e-9 L=60e-9 MR=1
MNM4 net15 BN VSS VPW nm1p2_svt_lp W=230e-9 L=60e-9 MR=1
MNM3 net18 AN VSS VPW nm1p2_svt_lp W=230e-9 L=60e-9 MR=1
MNM2 Y C VSS VPW nm1p2_svt_lp W=230e-9 L=60e-9 MR=1
MNM1 Y net15 VSS VPW nm1p2_svt_lp W=230e-9 L=60e-9 MR=1
MNM0 Y net18 VSS VPW nm1p2_svt_lp W=230e-9 L=60e-9 MR=1
.ENDS
.SUBCKT NOR3BBX2_9TSVT AN BN C VDD VSS Y VNW VPW
MPM4 net15 BN VDD VNW pm1p2_svt_lp W=590e-9 L=60e-9 MR=1
MPM3 net18 AN VDD VNW pm1p2_svt_lp W=590e-9 L=60e-9 MR=1
MPM2 net27 C VDD VNW pm1p2_svt_lp W=1.18e-6 L=60e-9 MR=1
MPM1 net28 net15 net27 VNW pm1p2_svt_lp W=1.18e-6 L=60e-9 MR=1
MPM0 Y net18 net28 VNW pm1p2_svt_lp W=1.18e-6 L=60e-9 MR=1
MNM4 net15 BN VSS VPW nm1p2_svt_lp W=230e-9 L=60e-9 MR=1
MNM3 net18 AN VSS VPW nm1p2_svt_lp W=230e-9 L=60e-9 MR=1
MNM2 Y C VSS VPW nm1p2_svt_lp W=460e-9 L=60e-9 MR=1
MNM1 Y net15 VSS VPW nm1p2_svt_lp W=460e-9 L=60e-9 MR=1
MNM0 Y net18 VSS VPW nm1p2_svt_lp W=460e-9 L=60e-9 MR=1
.ENDS
.SUBCKT NOR3BBX3_9TSVT AN BN C VDD VSS Y VNW VPW
MPM4 net15 BN VDD VNW pm1p2_svt_lp W=590e-9 L=60e-9 MR=1
MPM3 net18 AN VDD VNW pm1p2_svt_lp W=590e-9 L=60e-9 MR=1
MPM2 net27 C VDD VNW pm1p2_svt_lp W=1.77e-6 L=60e-9 MR=1
MPM1 net28 net15 net27 VNW pm1p2_svt_lp W=1.77e-6 L=60e-9 MR=1
MPM0 Y net18 net28 VNW pm1p2_svt_lp W=1.77e-6 L=60e-9 MR=1
MNM4 net15 BN VSS VPW nm1p2_svt_lp W=230e-9 L=60e-9 MR=1
MNM3 net18 AN VSS VPW nm1p2_svt_lp W=230e-9 L=60e-9 MR=1
MNM2 Y C VSS VPW nm1p2_svt_lp W=690e-9 L=60e-9 MR=1
MNM1 Y net15 VSS VPW nm1p2_svt_lp W=690e-9 L=60e-9 MR=1
MNM0 Y net18 VSS VPW nm1p2_svt_lp W=690e-9 L=60e-9 MR=1
.ENDS
.SUBCKT NOR3BBX4_9TSVT AN BN C VDD VSS Y VNW VPW
MPM4 net15 BN VDD VNW pm1p2_svt_lp W=1.18e-6 L=60e-9 MR=1
MPM3 net18 AN VDD VNW pm1p2_svt_lp W=1.18e-6 L=60e-9 MR=1
MPM2 net27 C VDD VNW pm1p2_svt_lp W=2.36e-6 L=60e-9 MR=1
MPM1 net28 net15 net27 VNW pm1p2_svt_lp W=2.36e-6 L=60e-9 MR=1
MPM0 Y net18 net28 VNW pm1p2_svt_lp W=2.36e-6 L=60e-9 MR=1
MNM4 net15 BN VSS VPW nm1p2_svt_lp W=460e-9 L=60e-9 MR=1
MNM3 net18 AN VSS VPW nm1p2_svt_lp W=460e-9 L=60e-9 MR=1
MNM2 Y C VSS VPW nm1p2_svt_lp W=920e-9 L=60e-9 MR=1
MNM1 Y net15 VSS VPW nm1p2_svt_lp W=920e-9 L=60e-9 MR=1
MNM0 Y net18 VSS VPW nm1p2_svt_lp W=920e-9 L=60e-9 MR=1
.ENDS
.SUBCKT NOR3BBX6_9TSVT AN BN C VDD VSS Y VNW VPW
MPM4 net15 BN VDD VNW pm1p2_svt_lp W=1.18e-6 L=60e-9 MR=1
MPM3 net18 AN VDD VNW pm1p2_svt_lp W=1.18e-6 L=60e-9 MR=1
MPM2 net27 C VDD VNW pm1p2_svt_lp W=3.54e-6 L=60e-9 MR=1
MPM1 net28 net15 net27 VNW pm1p2_svt_lp W=3.54e-6 L=60e-9 MR=1
MPM0 Y net18 net28 VNW pm1p2_svt_lp W=3.54e-6 L=60e-9 MR=1
MNM4 net15 BN VSS VPW nm1p2_svt_lp W=460e-9 L=60e-9 MR=1
MNM3 net18 AN VSS VPW nm1p2_svt_lp W=460e-9 L=60e-9 MR=1
MNM2 Y C VSS VPW nm1p2_svt_lp W=1.38e-6 L=60e-9 MR=1
MNM1 Y net15 VSS VPW nm1p2_svt_lp W=1.38e-6 L=60e-9 MR=1
MNM0 Y net18 VSS VPW nm1p2_svt_lp W=1.38e-6 L=60e-9 MR=1
.ENDS
.SUBCKT NOR3BBX8_9TSVT AN BN C VDD VSS Y VNW VPW
MPM4 net15 BN VDD VNW pm1p2_svt_lp W=1.77e-6 L=60e-9 MR=1
MPM3 net18 AN VDD VNW pm1p2_svt_lp W=1.77e-6 L=60e-9 MR=1
MPM2 net27 C VDD VNW pm1p2_svt_lp W=4.72e-6 L=60e-9 MR=1
MPM1 net28 net15 net27 VNW pm1p2_svt_lp W=4.72e-6 L=60e-9 MR=1
MPM0 Y net18 net28 VNW pm1p2_svt_lp W=4.72e-6 L=60e-9 MR=1
MNM4 net15 BN VSS VPW nm1p2_svt_lp W=690e-9 L=60e-9 MR=1
MNM3 net18 AN VSS VPW nm1p2_svt_lp W=690e-9 L=60e-9 MR=1
MNM2 Y C VSS VPW nm1p2_svt_lp W=1.84e-6 L=60e-9 MR=1
MNM1 Y net15 VSS VPW nm1p2_svt_lp W=1.84e-6 L=60e-9 MR=1
MNM0 Y net18 VSS VPW nm1p2_svt_lp W=1.84e-6 L=60e-9 MR=1
.ENDS
.SUBCKT NOR3BX0P5_9TSVT AN B C VDD VSS Y VNW VPW
MPM3 net15 AN VDD VNW pm1p2_svt_lp W=300e-9 L=60e-9 MR=1
MPM2 net24 C VDD VNW pm1p2_svt_lp W=300e-9 L=60e-9 MR=1
MPM1 net25 B net24 VNW pm1p2_svt_lp W=300e-9 L=60e-9 MR=1
MPM0 Y net15 net25 VNW pm1p2_svt_lp W=300e-9 L=60e-9 MR=1
MNM3 net15 AN VSS VPW nm1p2_svt_lp W=150e-9 L=60e-9 MR=1
MNM2 Y C VSS VPW nm1p2_svt_lp W=150e-9 L=60e-9 MR=1
MNM1 Y B VSS VPW nm1p2_svt_lp W=150e-9 L=60e-9 MR=1
MNM0 Y net15 VSS VPW nm1p2_svt_lp W=150e-9 L=60e-9 MR=1
.ENDS
.SUBCKT NOR3BX1_9TSVT AN B C VDD VSS Y VNW VPW
MPM3 net15 AN VDD VNW pm1p2_svt_lp W=590e-9 L=60e-9 MR=1
MPM2 net24 C VDD VNW pm1p2_svt_lp W=590e-9 L=60e-9 MR=1
MPM1 net25 B net24 VNW pm1p2_svt_lp W=590e-9 L=60e-9 MR=1
MPM0 Y net15 net25 VNW pm1p2_svt_lp W=590e-9 L=60e-9 MR=1
MNM3 net15 AN VSS VPW nm1p2_svt_lp W=230e-9 L=60e-9 MR=1
MNM2 Y C VSS VPW nm1p2_svt_lp W=230e-9 L=60e-9 MR=1
MNM1 Y B VSS VPW nm1p2_svt_lp W=230e-9 L=60e-9 MR=1
MNM0 Y net15 VSS VPW nm1p2_svt_lp W=230e-9 L=60e-9 MR=1
.ENDS
.SUBCKT NOR3BX2_9TSVT AN B C VDD VSS Y VNW VPW
MPM3 net15 AN VDD VNW pm1p2_svt_lp W=590e-9 L=60e-9 MR=1
MPM2 net24 C VDD VNW pm1p2_svt_lp W=1.18e-6 L=60e-9 MR=1
MPM1 net25 B net24 VNW pm1p2_svt_lp W=1.18e-6 L=60e-9 MR=1
MPM0 Y net15 net25 VNW pm1p2_svt_lp W=1.18e-6 L=60e-9 MR=1
MNM3 net15 AN VSS VPW nm1p2_svt_lp W=230e-9 L=60e-9 MR=1
MNM2 Y C VSS VPW nm1p2_svt_lp W=460e-9 L=60e-9 MR=1
MNM1 Y B VSS VPW nm1p2_svt_lp W=460e-9 L=60e-9 MR=1
MNM0 Y net15 VSS VPW nm1p2_svt_lp W=460e-9 L=60e-9 MR=1
.ENDS
.SUBCKT NOR3BX3_9TSVT AN B C VDD VSS Y VNW VPW
MPM3 net15 AN VDD VNW pm1p2_svt_lp W=590e-9 L=60e-9 MR=1
MPM2 net24 C VDD VNW pm1p2_svt_lp W=1.77e-6 L=60e-9 MR=1
MPM1 net25 B net24 VNW pm1p2_svt_lp W=1.77e-6 L=60e-9 MR=1
MPM0 Y net15 net25 VNW pm1p2_svt_lp W=1.77e-6 L=60e-9 MR=1
MNM3 net15 AN VSS VPW nm1p2_svt_lp W=230e-9 L=60e-9 MR=1
MNM2 Y C VSS VPW nm1p2_svt_lp W=690e-9 L=60e-9 MR=1
MNM1 Y B VSS VPW nm1p2_svt_lp W=690e-9 L=60e-9 MR=1
MNM0 Y net15 VSS VPW nm1p2_svt_lp W=690e-9 L=60e-9 MR=1
.ENDS
.SUBCKT NOR3BX4_9TSVT AN B C VDD VSS Y VNW VPW
MPM3 net15 AN VDD VNW pm1p2_svt_lp W=1.18e-6 L=60e-9 MR=1
MPM2 net24 C VDD VNW pm1p2_svt_lp W=2.36e-6 L=60e-9 MR=1
MPM1 net25 B net24 VNW pm1p2_svt_lp W=2.36e-6 L=60e-9 MR=1
MPM0 Y net15 net25 VNW pm1p2_svt_lp W=2.36e-6 L=60e-9 MR=1
MNM3 net15 AN VSS VPW nm1p2_svt_lp W=460e-9 L=60e-9 MR=1
MNM2 Y C VSS VPW nm1p2_svt_lp W=920e-9 L=60e-9 MR=1
MNM1 Y B VSS VPW nm1p2_svt_lp W=920e-9 L=60e-9 MR=1
MNM0 Y net15 VSS VPW nm1p2_svt_lp W=920e-9 L=60e-9 MR=1
.ENDS
.SUBCKT NOR3BX6_9TSVT AN B C VDD VSS Y VNW VPW
MPM3 net15 AN VDD VNW pm1p2_svt_lp W=1.18e-6 L=60e-9 MR=1
MPM2 net24 C VDD VNW pm1p2_svt_lp W=3.54e-6 L=60e-9 MR=1
MPM1 net25 B net24 VNW pm1p2_svt_lp W=3.54e-6 L=60e-9 MR=1
MPM0 Y net15 net25 VNW pm1p2_svt_lp W=3.54e-6 L=60e-9 MR=1
MNM3 net15 AN VSS VPW nm1p2_svt_lp W=460e-9 L=60e-9 MR=1
MNM2 Y C VSS VPW nm1p2_svt_lp W=1.38e-6 L=60e-9 MR=1
MNM1 Y B VSS VPW nm1p2_svt_lp W=1.38e-6 L=60e-9 MR=1
MNM0 Y net15 VSS VPW nm1p2_svt_lp W=1.38e-6 L=60e-9 MR=1
.ENDS
.SUBCKT NOR3BX8_9TSVT AN B C VDD VSS Y VNW VPW
MPM3 net15 AN VDD VNW pm1p2_svt_lp W=1.77e-6 L=60e-9 MR=1
MPM2 net24 C VDD VNW pm1p2_svt_lp W=4.72e-6 L=60e-9 MR=1
MPM1 net25 B net24 VNW pm1p2_svt_lp W=4.72e-6 L=60e-9 MR=1
MPM0 Y net15 net25 VNW pm1p2_svt_lp W=4.72e-6 L=60e-9 MR=1
MNM3 net15 AN VSS VPW nm1p2_svt_lp W=690e-9 L=60e-9 MR=1
MNM2 Y C VSS VPW nm1p2_svt_lp W=1.84e-6 L=60e-9 MR=1
MNM1 Y B VSS VPW nm1p2_svt_lp W=1.84e-6 L=60e-9 MR=1
MNM0 Y net15 VSS VPW nm1p2_svt_lp W=1.84e-6 L=60e-9 MR=1
.ENDS
.SUBCKT NOR3X0P5_9TSVT A B C VDD VSS Y VNW VPW
MPM2 net19 C VDD VNW pm1p2_svt_lp W=300e-9 L=60e-9 MR=1
MPM1 net20 B net19 VNW pm1p2_svt_lp W=300e-9 L=60e-9 MR=1
MPM0 Y A net20 VNW pm1p2_svt_lp W=300e-9 L=60e-9 MR=1
MNM2 Y C VSS VPW nm1p2_svt_lp W=150e-9 L=60e-9 MR=1
MNM1 Y B VSS VPW nm1p2_svt_lp W=150e-9 L=60e-9 MR=1
MNM0 Y A VSS VPW nm1p2_svt_lp W=150e-9 L=60e-9 MR=1
.ENDS
.SUBCKT NOR3X1_9TSVT A B C VDD VSS Y VNW VPW
MPM2 net19 C VDD VNW pm1p2_svt_lp W=590e-9 L=60e-9 MR=1
MPM1 net20 B net19 VNW pm1p2_svt_lp W=590e-9 L=60e-9 MR=1
MPM0 Y A net20 VNW pm1p2_svt_lp W=590e-9 L=60e-9 MR=1
MNM2 Y C VSS VPW nm1p2_svt_lp W=230e-9 L=60e-9 MR=1
MNM1 Y B VSS VPW nm1p2_svt_lp W=230e-9 L=60e-9 MR=1
MNM0 Y A VSS VPW nm1p2_svt_lp W=230e-9 L=60e-9 MR=1
.ENDS
.SUBCKT NOR3X2_9TSVT A B C VDD VSS Y VNW VPW
MPM2 net19 C VDD VNW pm1p2_svt_lp W=1.18e-6 L=60e-9 MR=1
MPM1 net20 B net19 VNW pm1p2_svt_lp W=1.18e-6 L=60e-9 MR=1
MPM0 Y A net20 VNW pm1p2_svt_lp W=1.18e-6 L=60e-9 MR=1
MNM2 Y C VSS VPW nm1p2_svt_lp W=460e-9 L=60e-9 MR=1
MNM1 Y B VSS VPW nm1p2_svt_lp W=460e-9 L=60e-9 MR=1
MNM0 Y A VSS VPW nm1p2_svt_lp W=460e-9 L=60e-9 MR=1
.ENDS
.SUBCKT NOR3X3_9TSVT A B C VDD VSS Y VNW VPW
MPM2 net19 C VDD VNW pm1p2_svt_lp W=1.77e-6 L=60e-9 MR=1
MPM1 net20 B net19 VNW pm1p2_svt_lp W=1.77e-6 L=60e-9 MR=1
MPM0 Y A net20 VNW pm1p2_svt_lp W=1.77e-6 L=60e-9 MR=1
MNM2 Y C VSS VPW nm1p2_svt_lp W=690e-9 L=60e-9 MR=1
MNM1 Y B VSS VPW nm1p2_svt_lp W=690e-9 L=60e-9 MR=1
MNM0 Y A VSS VPW nm1p2_svt_lp W=690e-9 L=60e-9 MR=1
.ENDS
.SUBCKT NOR3X4_9TSVT A B C VDD VSS Y VNW VPW
MPM2 net19 C VDD VNW pm1p2_svt_lp W=2.36e-6 L=60e-9 MR=1
MPM1 net20 B net19 VNW pm1p2_svt_lp W=2.36e-6 L=60e-9 MR=1
MPM0 Y A net20 VNW pm1p2_svt_lp W=2.36e-6 L=60e-9 MR=1
MNM2 Y C VSS VPW nm1p2_svt_lp W=920e-9 L=60e-9 MR=1
MNM1 Y B VSS VPW nm1p2_svt_lp W=920e-9 L=60e-9 MR=1
MNM0 Y A VSS VPW nm1p2_svt_lp W=920e-9 L=60e-9 MR=1
.ENDS
.SUBCKT NOR3X6_9TSVT A B C VDD VSS Y VNW VPW
MPM2 net19 C VDD VNW pm1p2_svt_lp W=3.54e-6 L=60e-9 MR=1
MPM1 net20 B net19 VNW pm1p2_svt_lp W=3.54e-6 L=60e-9 MR=1
MPM0 Y A net20 VNW pm1p2_svt_lp W=3.54e-6 L=60e-9 MR=1
MNM2 Y C VSS VPW nm1p2_svt_lp W=1.38e-6 L=60e-9 MR=1
MNM1 Y B VSS VPW nm1p2_svt_lp W=1.38e-6 L=60e-9 MR=1
MNM0 Y A VSS VPW nm1p2_svt_lp W=1.38e-6 L=60e-9 MR=1
.ENDS
.SUBCKT NOR3X8_9TSVT A B C VDD VSS Y VNW VPW
MPM2 net19 C VDD VNW pm1p2_svt_lp W=4.72e-6 L=60e-9 MR=1
MPM1 net20 B net19 VNW pm1p2_svt_lp W=4.72e-6 L=60e-9 MR=1
MPM0 Y A net20 VNW pm1p2_svt_lp W=4.72e-6 L=60e-9 MR=1
MNM2 Y C VSS VPW nm1p2_svt_lp W=1.84e-6 L=60e-9 MR=1
MNM1 Y B VSS VPW nm1p2_svt_lp W=1.84e-6 L=60e-9 MR=1
MNM0 Y A VSS VPW nm1p2_svt_lp W=1.84e-6 L=60e-9 MR=1
.ENDS
.SUBCKT NOR4BBX0P5_9TSVT AN BN C D VDD VSS Y VNW VPW
MPM5 net17 BN VDD VNW pm1p2_svt_lp W=300e-9 L=60e-9 MR=1
MPM4 net20 AN VDD VNW pm1p2_svt_lp W=300e-9 L=60e-9 MR=1
MPM3 net31 D VDD VNW pm1p2_svt_lp W=300e-9 L=60e-9 MR=1
MPM2 net32 C net31 VNW pm1p2_svt_lp W=300e-9 L=60e-9 MR=1
MPM1 net33 net17 net32 VNW pm1p2_svt_lp W=300e-9 L=60e-9 MR=1
MPM0 Y net20 net33 VNW pm1p2_svt_lp W=300e-9 L=60e-9 MR=1
MNM5 net17 BN VSS VPW nm1p2_svt_lp W=150e-9 L=60e-9 MR=1
MNM4 net20 AN VSS VPW nm1p2_svt_lp W=150e-9 L=60e-9 MR=1
MNM3 Y D VSS VPW nm1p2_svt_lp W=150e-9 L=60e-9 MR=1
MNM2 Y C VSS VPW nm1p2_svt_lp W=150e-9 L=60e-9 MR=1
MNM1 Y net17 VSS VPW nm1p2_svt_lp W=150e-9 L=60e-9 MR=1
MNM0 Y net20 VSS VPW nm1p2_svt_lp W=150e-9 L=60e-9 MR=1
.ENDS
.SUBCKT NOR4BBX1_9TSVT AN BN C D VDD VSS Y VNW VPW
MPM5 net17 BN VDD VNW pm1p2_svt_lp W=590e-9 L=60e-9 MR=1
MPM4 net20 AN VDD VNW pm1p2_svt_lp W=590e-9 L=60e-9 MR=1
MPM3 net31 D VDD VNW pm1p2_svt_lp W=590e-9 L=60e-9 MR=1
MPM2 net32 C net31 VNW pm1p2_svt_lp W=590e-9 L=60e-9 MR=1
MPM1 net33 net17 net32 VNW pm1p2_svt_lp W=590e-9 L=60e-9 MR=1
MPM0 Y net20 net33 VNW pm1p2_svt_lp W=590e-9 L=60e-9 MR=1
MNM5 net17 BN VSS VPW nm1p2_svt_lp W=230e-9 L=60e-9 MR=1
MNM4 net20 AN VSS VPW nm1p2_svt_lp W=230e-9 L=60e-9 MR=1
MNM3 Y D VSS VPW nm1p2_svt_lp W=230e-9 L=60e-9 MR=1
MNM2 Y C VSS VPW nm1p2_svt_lp W=230e-9 L=60e-9 MR=1
MNM1 Y net17 VSS VPW nm1p2_svt_lp W=230e-9 L=60e-9 MR=1
MNM0 Y net20 VSS VPW nm1p2_svt_lp W=230e-9 L=60e-9 MR=1
.ENDS
.SUBCKT NOR4BBX2_9TSVT AN BN C D VDD VSS Y VNW VPW
MPM5 net17 BN VDD VNW pm1p2_svt_lp W=590e-9 L=60e-9 MR=1
MPM4 net20 AN VDD VNW pm1p2_svt_lp W=590e-9 L=60e-9 MR=1
MPM3 net31 D VDD VNW pm1p2_svt_lp W=1.18e-6 L=60e-9 MR=1
MPM2 net32 C net31 VNW pm1p2_svt_lp W=1.18e-6 L=60e-9 MR=1
MPM1 net33 net17 net32 VNW pm1p2_svt_lp W=1.18e-6 L=60e-9 MR=1
MPM0 Y net20 net33 VNW pm1p2_svt_lp W=1.18e-6 L=60e-9 MR=1
MNM5 net17 BN VSS VPW nm1p2_svt_lp W=230e-9 L=60e-9 MR=1
MNM4 net20 AN VSS VPW nm1p2_svt_lp W=230e-9 L=60e-9 MR=1
MNM3 Y D VSS VPW nm1p2_svt_lp W=460e-9 L=60e-9 MR=1
MNM2 Y C VSS VPW nm1p2_svt_lp W=460e-9 L=60e-9 MR=1
MNM1 Y net17 VSS VPW nm1p2_svt_lp W=460e-9 L=60e-9 MR=1
MNM0 Y net20 VSS VPW nm1p2_svt_lp W=460e-9 L=60e-9 MR=1
.ENDS
.SUBCKT NOR4BBX3_9TSVT AN BN C D VDD VSS Y VNW VPW
MPM5 net17 BN VDD VNW pm1p2_svt_lp W=590e-9 L=60e-9 MR=1
MPM4 net20 AN VDD VNW pm1p2_svt_lp W=590e-9 L=60e-9 MR=1
MPM3 net31 D VDD VNW pm1p2_svt_lp W=1.77e-6 L=60e-9 MR=1
MPM2 net32 C net31 VNW pm1p2_svt_lp W=1.77e-6 L=60e-9 MR=1
MPM1 net33 net17 net32 VNW pm1p2_svt_lp W=1.77e-6 L=60e-9 MR=1
MPM0 Y net20 net33 VNW pm1p2_svt_lp W=1.77e-6 L=60e-9 MR=1
MNM5 net17 BN VSS VPW nm1p2_svt_lp W=230e-9 L=60e-9 MR=1
MNM4 net20 AN VSS VPW nm1p2_svt_lp W=230e-9 L=60e-9 MR=1
MNM3 Y D VSS VPW nm1p2_svt_lp W=690e-9 L=60e-9 MR=1
MNM2 Y C VSS VPW nm1p2_svt_lp W=690e-9 L=60e-9 MR=1
MNM1 Y net17 VSS VPW nm1p2_svt_lp W=690e-9 L=60e-9 MR=1
MNM0 Y net20 VSS VPW nm1p2_svt_lp W=690e-9 L=60e-9 MR=1
.ENDS
.SUBCKT NOR4BBX4_9TSVT AN BN C D VDD VSS Y VNW VPW
MPM5 net17 BN VDD VNW pm1p2_svt_lp W=1.18e-6 L=60e-9 MR=1
MPM4 net20 AN VDD VNW pm1p2_svt_lp W=1.18e-6 L=60e-9 MR=1
MPM3 net31 D VDD VNW pm1p2_svt_lp W=2.36e-6 L=60e-9 MR=1
MPM2 net32 C net31 VNW pm1p2_svt_lp W=2.36e-6 L=60e-9 MR=1
MPM1 net33 net17 net32 VNW pm1p2_svt_lp W=2.36e-6 L=60e-9 MR=1
MPM0 Y net20 net33 VNW pm1p2_svt_lp W=2.36e-6 L=60e-9 MR=1
MNM5 net17 BN VSS VPW nm1p2_svt_lp W=460e-9 L=60e-9 MR=1
MNM4 net20 AN VSS VPW nm1p2_svt_lp W=460e-9 L=60e-9 MR=1
MNM3 Y D VSS VPW nm1p2_svt_lp W=920e-9 L=60e-9 MR=1
MNM2 Y C VSS VPW nm1p2_svt_lp W=920e-9 L=60e-9 MR=1
MNM1 Y net17 VSS VPW nm1p2_svt_lp W=920e-9 L=60e-9 MR=1
MNM0 Y net20 VSS VPW nm1p2_svt_lp W=920e-9 L=60e-9 MR=1
.ENDS
.SUBCKT NOR4BBX6_9TSVT AN BN C D VDD VSS Y VNW VPW
MPM5 net17 BN VDD VNW pm1p2_svt_lp W=1.18e-6 L=60e-9 MR=1
MPM4 net20 AN VDD VNW pm1p2_svt_lp W=1.18e-6 L=60e-9 MR=1
MPM3 net31 D VDD VNW pm1p2_svt_lp W=3.54e-6 L=60e-9 MR=1
MPM2 net32 C net31 VNW pm1p2_svt_lp W=3.54e-6 L=60e-9 MR=1
MPM1 net33 net17 net32 VNW pm1p2_svt_lp W=3.54e-6 L=60e-9 MR=1
MPM0 Y net20 net33 VNW pm1p2_svt_lp W=3.54e-6 L=60e-9 MR=1
MNM5 net17 BN VSS VPW nm1p2_svt_lp W=460e-9 L=60e-9 MR=1
MNM4 net20 AN VSS VPW nm1p2_svt_lp W=460e-9 L=60e-9 MR=1
MNM3 Y D VSS VPW nm1p2_svt_lp W=1.38e-6 L=60e-9 MR=1
MNM2 Y C VSS VPW nm1p2_svt_lp W=1.38e-6 L=60e-9 MR=1
MNM1 Y net17 VSS VPW nm1p2_svt_lp W=1.38e-6 L=60e-9 MR=1
MNM0 Y net20 VSS VPW nm1p2_svt_lp W=1.38e-6 L=60e-9 MR=1
.ENDS
.SUBCKT NOR4BBX8_9TSVT AN BN C D VDD VSS Y VNW VPW
MPM5 net17 BN VDD VNW pm1p2_svt_lp W=1.77e-6 L=60e-9 MR=1
MPM4 net20 AN VDD VNW pm1p2_svt_lp W=1.77e-6 L=60e-9 MR=1
MPM3 net31 D VDD VNW pm1p2_svt_lp W=4.72e-6 L=60e-9 MR=1
MPM2 net32 C net31 VNW pm1p2_svt_lp W=4.72e-6 L=60e-9 MR=1
MPM1 net33 net17 net32 VNW pm1p2_svt_lp W=4.72e-6 L=60e-9 MR=1
MPM0 Y net20 net33 VNW pm1p2_svt_lp W=4.72e-6 L=60e-9 MR=1
MNM5 net17 BN VSS VPW nm1p2_svt_lp W=690e-9 L=60e-9 MR=1
MNM4 net20 AN VSS VPW nm1p2_svt_lp W=690e-9 L=60e-9 MR=1
MNM3 Y D VSS VPW nm1p2_svt_lp W=1.84e-6 L=60e-9 MR=1
MNM2 Y C VSS VPW nm1p2_svt_lp W=1.84e-6 L=60e-9 MR=1
MNM1 Y net17 VSS VPW nm1p2_svt_lp W=1.84e-6 L=60e-9 MR=1
MNM0 Y net20 VSS VPW nm1p2_svt_lp W=1.84e-6 L=60e-9 MR=1
.ENDS
.SUBCKT NOR4BX0P5_9TSVT AN B C D VDD VSS Y VNW VPW
MPM4 net17 AN VDD VNW pm1p2_svt_lp W=300e-9 L=60e-9 MR=1
MPM3 net28 D VDD VNW pm1p2_svt_lp W=300e-9 L=60e-9 MR=1
MPM2 net29 C net28 VNW pm1p2_svt_lp W=300e-9 L=60e-9 MR=1
MPM1 net30 B net29 VNW pm1p2_svt_lp W=300e-9 L=60e-9 MR=1
MPM0 Y net17 net30 VNW pm1p2_svt_lp W=300e-9 L=60e-9 MR=1
MNM4 net17 AN VSS VPW nm1p2_svt_lp W=150e-9 L=60e-9 MR=1
MNM3 Y D VSS VPW nm1p2_svt_lp W=150e-9 L=60e-9 MR=1
MNM2 Y C VSS VPW nm1p2_svt_lp W=150e-9 L=60e-9 MR=1
MNM1 Y B VSS VPW nm1p2_svt_lp W=150e-9 L=60e-9 MR=1
MNM0 Y net17 VSS VPW nm1p2_svt_lp W=150e-9 L=60e-9 MR=1
.ENDS
.SUBCKT NOR4BX1_9TSVT AN B C D VDD VSS Y VNW VPW
MPM4 net17 AN VDD VNW pm1p2_svt_lp W=590e-9 L=60e-9 MR=1
MPM3 net28 D VDD VNW pm1p2_svt_lp W=590e-9 L=60e-9 MR=1
MPM2 net29 C net28 VNW pm1p2_svt_lp W=590e-9 L=60e-9 MR=1
MPM1 net30 B net29 VNW pm1p2_svt_lp W=590e-9 L=60e-9 MR=1
MPM0 Y net17 net30 VNW pm1p2_svt_lp W=590e-9 L=60e-9 MR=1
MNM4 net17 AN VSS VPW nm1p2_svt_lp W=230e-9 L=60e-9 MR=1
MNM3 Y D VSS VPW nm1p2_svt_lp W=230e-9 L=60e-9 MR=1
MNM2 Y C VSS VPW nm1p2_svt_lp W=230e-9 L=60e-9 MR=1
MNM1 Y B VSS VPW nm1p2_svt_lp W=230e-9 L=60e-9 MR=1
MNM0 Y net17 VSS VPW nm1p2_svt_lp W=230e-9 L=60e-9 MR=1
.ENDS
.SUBCKT NOR4BX2_9TSVT AN B C D VDD VSS Y VNW VPW
MPM4 net17 AN VDD VNW pm1p2_svt_lp W=590e-9 L=60e-9 MR=1
MPM3 net28 D VDD VNW pm1p2_svt_lp W=1.18e-6 L=60e-9 MR=1
MPM2 net29 C net28 VNW pm1p2_svt_lp W=1.18e-6 L=60e-9 MR=1
MPM1 net30 B net29 VNW pm1p2_svt_lp W=1.18e-6 L=60e-9 MR=1
MPM0 Y net17 net30 VNW pm1p2_svt_lp W=1.18e-6 L=60e-9 MR=1
MNM4 net17 AN VSS VPW nm1p2_svt_lp W=230e-9 L=60e-9 MR=1
MNM3 Y D VSS VPW nm1p2_svt_lp W=460e-9 L=60e-9 MR=1
MNM2 Y C VSS VPW nm1p2_svt_lp W=460e-9 L=60e-9 MR=1
MNM1 Y B VSS VPW nm1p2_svt_lp W=460e-9 L=60e-9 MR=1
MNM0 Y net17 VSS VPW nm1p2_svt_lp W=460e-9 L=60e-9 MR=1
.ENDS
.SUBCKT NOR4BX3_9TSVT AN B C D VDD VSS Y VNW VPW
MPM4 net17 AN VDD VNW pm1p2_svt_lp W=590e-9 L=60e-9 MR=1
MPM3 net28 D VDD VNW pm1p2_svt_lp W=1.77e-6 L=60e-9 MR=1
MPM2 net29 C net28 VNW pm1p2_svt_lp W=1.77e-6 L=60e-9 MR=1
MPM1 net30 B net29 VNW pm1p2_svt_lp W=1.77e-6 L=60e-9 MR=1
MPM0 Y net17 net30 VNW pm1p2_svt_lp W=1.77e-6 L=60e-9 MR=1
MNM4 net17 AN VSS VPW nm1p2_svt_lp W=230e-9 L=60e-9 MR=1
MNM3 Y D VSS VPW nm1p2_svt_lp W=690e-9 L=60e-9 MR=1
MNM2 Y C VSS VPW nm1p2_svt_lp W=690e-9 L=60e-9 MR=1
MNM1 Y B VSS VPW nm1p2_svt_lp W=690e-9 L=60e-9 MR=1
MNM0 Y net17 VSS VPW nm1p2_svt_lp W=690e-9 L=60e-9 MR=1
.ENDS
.SUBCKT NOR4BX4_9TSVT AN B C D VDD VSS Y VNW VPW
MPM4 net17 AN VDD VNW pm1p2_svt_lp W=1.18e-6 L=60e-9 MR=1
MPM3 net28 D VDD VNW pm1p2_svt_lp W=2.36e-6 L=60e-9 MR=1
MPM2 net29 C net28 VNW pm1p2_svt_lp W=2.36e-6 L=60e-9 MR=1
MPM1 net30 B net29 VNW pm1p2_svt_lp W=2.36e-6 L=60e-9 MR=1
MPM0 Y net17 net30 VNW pm1p2_svt_lp W=2.36e-6 L=60e-9 MR=1
MNM4 net17 AN VSS VPW nm1p2_svt_lp W=460e-9 L=60e-9 MR=1
MNM3 Y D VSS VPW nm1p2_svt_lp W=920e-9 L=60e-9 MR=1
MNM2 Y C VSS VPW nm1p2_svt_lp W=920e-9 L=60e-9 MR=1
MNM1 Y B VSS VPW nm1p2_svt_lp W=920e-9 L=60e-9 MR=1
MNM0 Y net17 VSS VPW nm1p2_svt_lp W=920e-9 L=60e-9 MR=1
.ENDS
.SUBCKT NOR4BX6_9TSVT AN B C D VDD VSS Y VNW VPW
MPM4 net17 AN VDD VNW pm1p2_svt_lp W=1.18e-6 L=60e-9 MR=1
MPM3 net28 D VDD VNW pm1p2_svt_lp W=3.54e-6 L=60e-9 MR=1
MPM2 net29 C net28 VNW pm1p2_svt_lp W=3.54e-6 L=60e-9 MR=1
MPM1 net30 B net29 VNW pm1p2_svt_lp W=3.54e-6 L=60e-9 MR=1
MPM0 Y net17 net30 VNW pm1p2_svt_lp W=3.54e-6 L=60e-9 MR=1
MNM4 net17 AN VSS VPW nm1p2_svt_lp W=460e-9 L=60e-9 MR=1
MNM3 Y D VSS VPW nm1p2_svt_lp W=1.38e-6 L=60e-9 MR=1
MNM2 Y C VSS VPW nm1p2_svt_lp W=1.38e-6 L=60e-9 MR=1
MNM1 Y B VSS VPW nm1p2_svt_lp W=1.38e-6 L=60e-9 MR=1
MNM0 Y net17 VSS VPW nm1p2_svt_lp W=1.38e-6 L=60e-9 MR=1
.ENDS
.SUBCKT NOR4BX8_9TSVT AN B C D VDD VSS Y VNW VPW
MPM4 net17 AN VDD VNW pm1p2_svt_lp W=1.77e-6 L=60e-9 MR=1
MPM3 net28 D VDD VNW pm1p2_svt_lp W=4.72e-6 L=60e-9 MR=1
MPM2 net29 C net28 VNW pm1p2_svt_lp W=4.72e-6 L=60e-9 MR=1
MPM1 net30 B net29 VNW pm1p2_svt_lp W=4.72e-6 L=60e-9 MR=1
MPM0 Y net17 net30 VNW pm1p2_svt_lp W=4.72e-6 L=60e-9 MR=1
MNM4 net17 AN VSS VPW nm1p2_svt_lp W=690e-9 L=60e-9 MR=1
MNM3 Y D VSS VPW nm1p2_svt_lp W=1.84e-6 L=60e-9 MR=1
MNM2 Y C VSS VPW nm1p2_svt_lp W=1.84e-6 L=60e-9 MR=1
MNM1 Y B VSS VPW nm1p2_svt_lp W=1.84e-6 L=60e-9 MR=1
MNM0 Y net17 VSS VPW nm1p2_svt_lp W=1.84e-6 L=60e-9 MR=1
.ENDS
.SUBCKT NOR4X0P5_9TSVT A B C D VDD VSS Y VNW VPW
MPM3 net22 D VDD VNW pm1p2_svt_lp W=300e-9 L=60e-9 MR=1
MPM2 net23 C net22 VNW pm1p2_svt_lp W=300e-9 L=60e-9 MR=1
MPM1 net24 B net23 VNW pm1p2_svt_lp W=300e-9 L=60e-9 MR=1
MPM0 Y A net24 VNW pm1p2_svt_lp W=300e-9 L=60e-9 MR=1
MNM3 Y D VSS VPW nm1p2_svt_lp W=150e-9 L=60e-9 MR=1
MNM2 Y C VSS VPW nm1p2_svt_lp W=150e-9 L=60e-9 MR=1
MNM1 Y B VSS VPW nm1p2_svt_lp W=150e-9 L=60e-9 MR=1
MNM0 Y A VSS VPW nm1p2_svt_lp W=150e-9 L=60e-9 MR=1
.ENDS
.SUBCKT NOR4X1_9TSVT A B C D VDD VSS Y VNW VPW
MPM3 net22 D VDD VNW pm1p2_svt_lp W=590e-9 L=60e-9 MR=1
MPM2 net23 C net22 VNW pm1p2_svt_lp W=590e-9 L=60e-9 MR=1
MPM1 net24 B net23 VNW pm1p2_svt_lp W=590e-9 L=60e-9 MR=1
MPM0 Y A net24 VNW pm1p2_svt_lp W=590e-9 L=60e-9 MR=1
MNM3 Y D VSS VPW nm1p2_svt_lp W=230e-9 L=60e-9 MR=1
MNM2 Y C VSS VPW nm1p2_svt_lp W=230e-9 L=60e-9 MR=1
MNM1 Y B VSS VPW nm1p2_svt_lp W=230e-9 L=60e-9 MR=1
MNM0 Y A VSS VPW nm1p2_svt_lp W=230e-9 L=60e-9 MR=1
.ENDS
.SUBCKT NOR4X2_9TSVT A B C D VDD VSS Y VNW VPW
MPM3 net22 D VDD VNW pm1p2_svt_lp W=1.18e-6 L=60e-9 MR=1
MPM2 net23 C net22 VNW pm1p2_svt_lp W=1.18e-6 L=60e-9 MR=1
MPM1 net24 B net23 VNW pm1p2_svt_lp W=1.18e-6 L=60e-9 MR=1
MPM0 Y A net24 VNW pm1p2_svt_lp W=1.18e-6 L=60e-9 MR=1
MNM3 Y D VSS VPW nm1p2_svt_lp W=460e-9 L=60e-9 MR=1
MNM2 Y C VSS VPW nm1p2_svt_lp W=460e-9 L=60e-9 MR=1
MNM1 Y B VSS VPW nm1p2_svt_lp W=460e-9 L=60e-9 MR=1
MNM0 Y A VSS VPW nm1p2_svt_lp W=460e-9 L=60e-9 MR=1
.ENDS
.SUBCKT NOR4X3_9TSVT A B C D VDD VSS Y VNW VPW
MPM3 net22 D VDD VNW pm1p2_svt_lp W=1.77e-6 L=60e-9 MR=1
MPM2 net23 C net22 VNW pm1p2_svt_lp W=1.77e-6 L=60e-9 MR=1
MPM1 net24 B net23 VNW pm1p2_svt_lp W=1.77e-6 L=60e-9 MR=1
MPM0 Y A net24 VNW pm1p2_svt_lp W=1.77e-6 L=60e-9 MR=1
MNM3 Y D VSS VPW nm1p2_svt_lp W=690e-9 L=60e-9 MR=1
MNM2 Y C VSS VPW nm1p2_svt_lp W=690e-9 L=60e-9 MR=1
MNM1 Y B VSS VPW nm1p2_svt_lp W=690e-9 L=60e-9 MR=1
MNM0 Y A VSS VPW nm1p2_svt_lp W=690e-9 L=60e-9 MR=1
.ENDS
.SUBCKT NOR4X4_9TSVT A B C D VDD VSS Y VNW VPW
MPM3 net22 D VDD VNW pm1p2_svt_lp W=2.36e-6 L=60e-9 MR=1
MPM2 net23 C net22 VNW pm1p2_svt_lp W=2.36e-6 L=60e-9 MR=1
MPM1 net24 B net23 VNW pm1p2_svt_lp W=2.36e-6 L=60e-9 MR=1
MPM0 Y A net24 VNW pm1p2_svt_lp W=2.36e-6 L=60e-9 MR=1
MNM3 Y D VSS VPW nm1p2_svt_lp W=920e-9 L=60e-9 MR=1
MNM2 Y C VSS VPW nm1p2_svt_lp W=920e-9 L=60e-9 MR=1
MNM1 Y B VSS VPW nm1p2_svt_lp W=920e-9 L=60e-9 MR=1
MNM0 Y A VSS VPW nm1p2_svt_lp W=920e-9 L=60e-9 MR=1
.ENDS
.SUBCKT NOR4X6_9TSVT A B C D VDD VSS Y VNW VPW
MPM3 net22 D VDD VNW pm1p2_svt_lp W=3.54e-6 L=60e-9 MR=1
MPM2 net23 C net22 VNW pm1p2_svt_lp W=3.54e-6 L=60e-9 MR=1
MPM1 net24 B net23 VNW pm1p2_svt_lp W=3.54e-6 L=60e-9 MR=1
MPM0 Y A net24 VNW pm1p2_svt_lp W=3.54e-6 L=60e-9 MR=1
MNM3 Y D VSS VPW nm1p2_svt_lp W=1.38e-6 L=60e-9 MR=1
MNM2 Y C VSS VPW nm1p2_svt_lp W=1.38e-6 L=60e-9 MR=1
MNM1 Y B VSS VPW nm1p2_svt_lp W=1.38e-6 L=60e-9 MR=1
MNM0 Y A VSS VPW nm1p2_svt_lp W=1.38e-6 L=60e-9 MR=1
.ENDS
.SUBCKT NOR4X8_9TSVT A B C D VDD VSS Y VNW VPW
MPM3 net22 D VDD VNW pm1p2_svt_lp W=4.72e-6 L=60e-9 MR=1
MPM2 net23 C net22 VNW pm1p2_svt_lp W=4.72e-6 L=60e-9 MR=1
MPM1 net24 B net23 VNW pm1p2_svt_lp W=4.72e-6 L=60e-9 MR=1
MPM0 Y A net24 VNW pm1p2_svt_lp W=4.72e-6 L=60e-9 MR=1
MNM3 Y D VSS VPW nm1p2_svt_lp W=1.84e-6 L=60e-9 MR=1
MNM2 Y C VSS VPW nm1p2_svt_lp W=1.84e-6 L=60e-9 MR=1
MNM1 Y B VSS VPW nm1p2_svt_lp W=1.84e-6 L=60e-9 MR=1
MNM0 Y A VSS VPW nm1p2_svt_lp W=1.84e-6 L=60e-9 MR=1
.ENDS
.SUBCKT OA211X0P5_9TSVT A0 A1 B0 C0 VDD VSS Y VNW VPW
MNM4 Y net18 VSS VPW nm1p2_svt_lp W=230e-9 L=60e-9 MR=1
MNM3 net25 C0 VSS VPW nm1p2_svt_lp W=230e-9 L=60e-9 MR=1
MNM2 net15 B0 net25 VPW nm1p2_svt_lp W=230e-9 L=60e-9 MR=1
MNM1 net18 A1 net15 VPW nm1p2_svt_lp W=230e-9 L=60e-9 MR=1
MNM0 net18 A0 net15 VPW nm1p2_svt_lp W=230e-9 L=60e-9 MR=1
MPM4 Y net18 VDD VNW pm1p2_svt_lp W=300e-9 L=60e-9 MR=1
MPM3 net18 C0 VDD VNW pm1p2_svt_lp W=300e-9 L=60e-9 MR=1
MPM2 net18 B0 VDD VNW pm1p2_svt_lp W=300e-9 L=60e-9 MR=1
MPM1 net26 A1 VDD VNW pm1p2_svt_lp W=300e-9 L=60e-9 MR=1
MPM0 net18 A0 net26 VNW pm1p2_svt_lp W=300e-9 L=60e-9 MR=1
.ENDS
.SUBCKT OA211X1_9TSVT A0 A1 B0 C0 VDD VSS Y VNW VPW
MNM4 Y net18 VSS VPW nm1p2_svt_lp W=470e-9 L=60e-9 MR=1
MNM3 net25 C0 VSS VPW nm1p2_svt_lp W=470e-9 L=60e-9 MR=1
MNM2 net15 B0 net25 VPW nm1p2_svt_lp W=470e-9 L=60e-9 MR=1
MNM1 net18 A1 net15 VPW nm1p2_svt_lp W=470e-9 L=60e-9 MR=1
MNM0 net18 A0 net15 VPW nm1p2_svt_lp W=470e-9 L=60e-9 MR=1
MPM4 Y net18 VDD VNW pm1p2_svt_lp W=590e-9 L=60e-9 MR=1
MPM3 net18 C0 VDD VNW pm1p2_svt_lp W=590e-9 L=60e-9 MR=1
MPM2 net18 B0 VDD VNW pm1p2_svt_lp W=590e-9 L=60e-9 MR=1
MPM1 net26 A1 VDD VNW pm1p2_svt_lp W=590e-9 L=60e-9 MR=1
MPM0 net18 A0 net26 VNW pm1p2_svt_lp W=590e-9 L=60e-9 MR=1
.ENDS
.SUBCKT OA211X2_9TSVT A0 A1 B0 C0 VDD VSS Y VNW VPW
MNM4 Y net18 VSS VPW nm1p2_svt_lp W=940e-9 L=60e-9 MR=1
MNM3 net25 C0 VSS VPW nm1p2_svt_lp W=470e-9 L=60e-9 MR=1
MNM2 net15 B0 net25 VPW nm1p2_svt_lp W=470e-9 L=60e-9 MR=1
MNM1 net18 A1 net15 VPW nm1p2_svt_lp W=470e-9 L=60e-9 MR=1
MNM0 net18 A0 net15 VPW nm1p2_svt_lp W=470e-9 L=60e-9 MR=1
MPM4 Y net18 VDD VNW pm1p2_svt_lp W=1.18e-6 L=60e-9 MR=1
MPM3 net18 C0 VDD VNW pm1p2_svt_lp W=590e-9 L=60e-9 MR=1
MPM2 net18 B0 VDD VNW pm1p2_svt_lp W=590e-9 L=60e-9 MR=1
MPM1 net26 A1 VDD VNW pm1p2_svt_lp W=590e-9 L=60e-9 MR=1
MPM0 net18 A0 net26 VNW pm1p2_svt_lp W=590e-9 L=60e-9 MR=1
.ENDS
.SUBCKT OA211X4_9TSVT A0 A1 B0 C0 VDD VSS Y VNW VPW
MNM4 Y net18 VSS VPW nm1p2_svt_lp W=1.88e-6 L=60e-9 MR=1
MNM3 net25 C0 VSS VPW nm1p2_svt_lp W=940e-9 L=60e-9 MR=1
MNM2 net15 B0 net25 VPW nm1p2_svt_lp W=940e-9 L=60e-9 MR=1
MNM1 net18 A1 net15 VPW nm1p2_svt_lp W=940e-9 L=60e-9 MR=1
MNM0 net18 A0 net15 VPW nm1p2_svt_lp W=940e-9 L=60e-9 MR=1
MPM4 Y net18 VDD VNW pm1p2_svt_lp W=2.36e-6 L=60e-9 MR=1
MPM3 net18 C0 VDD VNW pm1p2_svt_lp W=1.18e-6 L=60e-9 MR=1
MPM2 net18 B0 VDD VNW pm1p2_svt_lp W=1.18e-6 L=60e-9 MR=1
MPM1 net26 A1 VDD VNW pm1p2_svt_lp W=1.18e-6 L=60e-9 MR=1
MPM0 net18 A0 net26 VNW pm1p2_svt_lp W=1.18e-6 L=60e-9 MR=1
.ENDS
.SUBCKT OA21X0P5_9TSVT A0 A1 B0 VDD VSS Y VNW VPW
MNM3 Y net16 VSS VPW nm1p2_svt_lp W=230e-9 L=60e-9 MR=1
MNM2 net13 B0 VSS VPW nm1p2_svt_lp W=230e-9 L=60e-9 MR=1
MNM1 net16 A1 net13 VPW nm1p2_svt_lp W=230e-9 L=60e-9 MR=1
MNM0 net16 A0 net13 VPW nm1p2_svt_lp W=230e-9 L=60e-9 MR=1
MPM3 Y net16 VDD VNW pm1p2_svt_lp W=300e-9 L=60e-9 MR=1
MPM2 net16 B0 VDD VNW pm1p2_svt_lp W=300e-9 L=60e-9 MR=1
MPM1 net22 A1 VDD VNW pm1p2_svt_lp W=300e-9 L=60e-9 MR=1
MPM0 net16 A0 net22 VNW pm1p2_svt_lp W=300e-9 L=60e-9 MR=1
.ENDS
.SUBCKT OA21X1_9TSVT A0 A1 B0 VDD VSS Y VNW VPW
MNM3 Y net16 VSS VPW nm1p2_svt_lp W=470e-9 L=60e-9 MR=1
MNM2 net13 B0 VSS VPW nm1p2_svt_lp W=470e-9 L=60e-9 MR=1
MNM1 net16 A1 net13 VPW nm1p2_svt_lp W=470e-9 L=60e-9 MR=1
MNM0 net16 A0 net13 VPW nm1p2_svt_lp W=470e-9 L=60e-9 MR=1
MPM3 Y net16 VDD VNW pm1p2_svt_lp W=590e-9 L=60e-9 MR=1
MPM2 net16 B0 VDD VNW pm1p2_svt_lp W=590e-9 L=60e-9 MR=1
MPM1 net22 A1 VDD VNW pm1p2_svt_lp W=590e-9 L=60e-9 MR=1
MPM0 net16 A0 net22 VNW pm1p2_svt_lp W=590e-9 L=60e-9 MR=1
.ENDS
.SUBCKT OA21X2_9TSVT A0 A1 B0 VDD VSS Y VNW VPW
MNM3 Y net16 VSS VPW nm1p2_svt_lp W=940e-9 L=60e-9 MR=1
MNM2 net13 B0 VSS VPW nm1p2_svt_lp W=470e-9 L=60e-9 MR=1
MNM1 net16 A1 net13 VPW nm1p2_svt_lp W=470e-9 L=60e-9 MR=1
MNM0 net16 A0 net13 VPW nm1p2_svt_lp W=470e-9 L=60e-9 MR=1
MPM3 Y net16 VDD VNW pm1p2_svt_lp W=1.18e-6 L=60e-9 MR=1
MPM2 net16 B0 VDD VNW pm1p2_svt_lp W=590e-9 L=60e-9 MR=1
MPM1 net22 A1 VDD VNW pm1p2_svt_lp W=590e-9 L=60e-9 MR=1
MPM0 net16 A0 net22 VNW pm1p2_svt_lp W=590e-9 L=60e-9 MR=1
.ENDS
.SUBCKT OA21X4_9TSVT A0 A1 B0 VDD VSS Y VNW VPW
MNM3 Y net16 VSS VPW nm1p2_svt_lp W=1.88e-6 L=60e-9 MR=1
MNM2 net13 B0 VSS VPW nm1p2_svt_lp W=940e-9 L=60e-9 MR=1
MNM1 net16 A1 net13 VPW nm1p2_svt_lp W=940e-9 L=60e-9 MR=1
MNM0 net16 A0 net13 VPW nm1p2_svt_lp W=940e-9 L=60e-9 MR=1
MPM3 Y net16 VDD VNW pm1p2_svt_lp W=2.36e-6 L=60e-9 MR=1
MPM2 net16 B0 VDD VNW pm1p2_svt_lp W=1.18e-6 L=60e-9 MR=1
MPM1 net22 A1 VDD VNW pm1p2_svt_lp W=1.18e-6 L=60e-9 MR=1
MPM0 net16 A0 net22 VNW pm1p2_svt_lp W=1.18e-6 L=60e-9 MR=1
.ENDS
.SUBCKT OA221X0P5_9TSVT A0 A1 B0 B1 C0 VDD VSS Y VNW VPW
MNM5 Y net22 VSS VPW nm1p2_svt_lp W=230e-9 L=60e-9 MR=1
MNM4 net17 C0 VSS VPW nm1p2_svt_lp W=230e-9 L=60e-9 MR=1
MNM3 net18 B1 net17 VPW nm1p2_svt_lp W=230e-9 L=60e-9 MR=1
MNM2 net18 B0 net17 VPW nm1p2_svt_lp W=230e-9 L=60e-9 MR=1
MNM1 net22 A1 net18 VPW nm1p2_svt_lp W=230e-9 L=60e-9 MR=1
MNM0 net22 A0 net18 VPW nm1p2_svt_lp W=230e-9 L=60e-9 MR=1
MPM5 Y net22 VDD VNW pm1p2_svt_lp W=300e-9 L=60e-9 MR=1
MPM4 net22 C0 VDD VNW pm1p2_svt_lp W=300e-9 L=60e-9 MR=1
MPM3 net30 B1 VDD VNW pm1p2_svt_lp W=300e-9 L=60e-9 MR=1
MPM2 net22 B0 net30 VNW pm1p2_svt_lp W=300e-9 L=60e-9 MR=1
MPM1 net31 A1 VDD VNW pm1p2_svt_lp W=300e-9 L=60e-9 MR=1
MPM0 net22 A0 net31 VNW pm1p2_svt_lp W=300e-9 L=60e-9 MR=1
.ENDS
.SUBCKT OA221X1_9TSVT A0 A1 B0 B1 C0 VDD VSS Y VNW VPW
MNM5 Y net22 VSS VPW nm1p2_svt_lp W=470e-9 L=60e-9 MR=1
MNM4 net17 C0 VSS VPW nm1p2_svt_lp W=470e-9 L=60e-9 MR=1
MNM3 net18 B1 net17 VPW nm1p2_svt_lp W=470e-9 L=60e-9 MR=1
MNM2 net18 B0 net17 VPW nm1p2_svt_lp W=470e-9 L=60e-9 MR=1
MNM1 net22 A1 net18 VPW nm1p2_svt_lp W=470e-9 L=60e-9 MR=1
MNM0 net22 A0 net18 VPW nm1p2_svt_lp W=470e-9 L=60e-9 MR=1
MPM5 Y net22 VDD VNW pm1p2_svt_lp W=590e-9 L=60e-9 MR=1
MPM4 net22 C0 VDD VNW pm1p2_svt_lp W=590e-9 L=60e-9 MR=1
MPM3 net30 B1 VDD VNW pm1p2_svt_lp W=590e-9 L=60e-9 MR=1
MPM2 net22 B0 net30 VNW pm1p2_svt_lp W=590e-9 L=60e-9 MR=1
MPM1 net31 A1 VDD VNW pm1p2_svt_lp W=590e-9 L=60e-9 MR=1
MPM0 net22 A0 net31 VNW pm1p2_svt_lp W=590e-9 L=60e-9 MR=1
.ENDS
.SUBCKT OA221X2_9TSVT A0 A1 B0 B1 C0 VDD VSS Y VNW VPW
MNM5 Y net22 VSS VPW nm1p2_svt_lp W=940e-9 L=60e-9 MR=1
MNM4 net17 C0 VSS VPW nm1p2_svt_lp W=470e-9 L=60e-9 MR=1
MNM3 net18 B1 net17 VPW nm1p2_svt_lp W=470e-9 L=60e-9 MR=1
MNM2 net18 B0 net17 VPW nm1p2_svt_lp W=470e-9 L=60e-9 MR=1
MNM1 net22 A1 net18 VPW nm1p2_svt_lp W=470e-9 L=60e-9 MR=1
MNM0 net22 A0 net18 VPW nm1p2_svt_lp W=470e-9 L=60e-9 MR=1
MPM5 Y net22 VDD VNW pm1p2_svt_lp W=1.18e-6 L=60e-9 MR=1
MPM4 net22 C0 VDD VNW pm1p2_svt_lp W=590e-9 L=60e-9 MR=1
MPM3 net30 B1 VDD VNW pm1p2_svt_lp W=590e-9 L=60e-9 MR=1
MPM2 net22 B0 net30 VNW pm1p2_svt_lp W=590e-9 L=60e-9 MR=1
MPM1 net31 A1 VDD VNW pm1p2_svt_lp W=590e-9 L=60e-9 MR=1
MPM0 net22 A0 net31 VNW pm1p2_svt_lp W=590e-9 L=60e-9 MR=1
.ENDS
.SUBCKT OA221X4_9TSVT A0 A1 B0 B1 C0 VDD VSS Y VNW VPW
MNM5 Y net22 VSS VPW nm1p2_svt_lp W=1.88e-6 L=60e-9 MR=1
MNM4 net17 C0 VSS VPW nm1p2_svt_lp W=940e-9 L=60e-9 MR=1
MNM3 net18 B1 net17 VPW nm1p2_svt_lp W=940e-9 L=60e-9 MR=1
MNM2 net18 B0 net17 VPW nm1p2_svt_lp W=940e-9 L=60e-9 MR=1
MNM1 net22 A1 net18 VPW nm1p2_svt_lp W=940e-9 L=60e-9 MR=1
MNM0 net22 A0 net18 VPW nm1p2_svt_lp W=940e-9 L=60e-9 MR=1
MPM5 Y net22 VDD VNW pm1p2_svt_lp W=2.36e-6 L=60e-9 MR=1
MPM4 net22 C0 VDD VNW pm1p2_svt_lp W=1.18e-6 L=60e-9 MR=1
MPM3 net30 B1 VDD VNW pm1p2_svt_lp W=1.18e-6 L=60e-9 MR=1
MPM2 net22 B0 net30 VNW pm1p2_svt_lp W=1.18e-6 L=60e-9 MR=1
MPM1 net31 A1 VDD VNW pm1p2_svt_lp W=1.18e-6 L=60e-9 MR=1
MPM0 net22 A0 net31 VNW pm1p2_svt_lp W=1.18e-6 L=60e-9 MR=1
.ENDS
.SUBCKT OA222X0P5_9TSVT A0 A1 B0 B1 C0 C1 VDD VSS Y VNW VPW
MNM6 Y net25 VSS VPW nm1p2_svt_lp W=230e-9 L=60e-9 MR=1
MNM5 net19 C1 VSS VPW nm1p2_svt_lp W=230e-9 L=60e-9 MR=1
MNM4 net19 C0 VSS VPW nm1p2_svt_lp W=230e-9 L=60e-9 MR=1
MNM3 net20 B1 net19 VPW nm1p2_svt_lp W=230e-9 L=60e-9 MR=1
MNM2 net20 B0 net19 VPW nm1p2_svt_lp W=230e-9 L=60e-9 MR=1
MNM1 net25 A1 net20 VPW nm1p2_svt_lp W=230e-9 L=60e-9 MR=1
MNM0 net25 A0 net20 VPW nm1p2_svt_lp W=230e-9 L=60e-9 MR=1
MPM6 Y net25 VDD VNW pm1p2_svt_lp W=300e-9 L=60e-9 MR=1
MPM5 net33 C1 VDD VNW pm1p2_svt_lp W=300e-9 L=60e-9 MR=1
MPM4 net25 C0 net33 VNW pm1p2_svt_lp W=300e-9 L=60e-9 MR=1
MPM3 net34 B1 VDD VNW pm1p2_svt_lp W=300e-9 L=60e-9 MR=1
MPM2 net25 B0 net34 VNW pm1p2_svt_lp W=300e-9 L=60e-9 MR=1
MPM1 net35 A1 VDD VNW pm1p2_svt_lp W=300e-9 L=60e-9 MR=1
MPM0 net25 A0 net35 VNW pm1p2_svt_lp W=300e-9 L=60e-9 MR=1
.ENDS
.SUBCKT OA222X1_9TSVT A0 A1 B0 B1 C0 C1 VDD VSS Y VNW VPW
MNM6 Y net25 VSS VPW nm1p2_svt_lp W=470e-9 L=60e-9 MR=1
MNM5 net19 C1 VSS VPW nm1p2_svt_lp W=470e-9 L=60e-9 MR=1
MNM4 net19 C0 VSS VPW nm1p2_svt_lp W=470e-9 L=60e-9 MR=1
MNM3 net20 B1 net19 VPW nm1p2_svt_lp W=470e-9 L=60e-9 MR=1
MNM2 net20 B0 net19 VPW nm1p2_svt_lp W=470e-9 L=60e-9 MR=1
MNM1 net25 A1 net20 VPW nm1p2_svt_lp W=470e-9 L=60e-9 MR=1
MNM0 net25 A0 net20 VPW nm1p2_svt_lp W=470e-9 L=60e-9 MR=1
MPM6 Y net25 VDD VNW pm1p2_svt_lp W=590e-9 L=60e-9 MR=1
MPM5 net33 C1 VDD VNW pm1p2_svt_lp W=590e-9 L=60e-9 MR=1
MPM4 net25 C0 net33 VNW pm1p2_svt_lp W=590e-9 L=60e-9 MR=1
MPM3 net34 B1 VDD VNW pm1p2_svt_lp W=590e-9 L=60e-9 MR=1
MPM2 net25 B0 net34 VNW pm1p2_svt_lp W=590e-9 L=60e-9 MR=1
MPM1 net35 A1 VDD VNW pm1p2_svt_lp W=590e-9 L=60e-9 MR=1
MPM0 net25 A0 net35 VNW pm1p2_svt_lp W=590e-9 L=60e-9 MR=1
.ENDS
.SUBCKT OA222X2_9TSVT A0 A1 B0 B1 C0 C1 VDD VSS Y VNW VPW
MNM6 Y net25 VSS VPW nm1p2_svt_lp W=940e-9 L=60e-9 MR=1
MNM5 net19 C1 VSS VPW nm1p2_svt_lp W=470e-9 L=60e-9 MR=1
MNM4 net19 C0 VSS VPW nm1p2_svt_lp W=470e-9 L=60e-9 MR=1
MNM3 net20 B1 net19 VPW nm1p2_svt_lp W=470e-9 L=60e-9 MR=1
MNM2 net20 B0 net19 VPW nm1p2_svt_lp W=470e-9 L=60e-9 MR=1
MNM1 net25 A1 net20 VPW nm1p2_svt_lp W=470e-9 L=60e-9 MR=1
MNM0 net25 A0 net20 VPW nm1p2_svt_lp W=470e-9 L=60e-9 MR=1
MPM6 Y net25 VDD VNW pm1p2_svt_lp W=1.18e-6 L=60e-9 MR=1
MPM5 net33 C1 VDD VNW pm1p2_svt_lp W=590e-9 L=60e-9 MR=1
MPM4 net25 C0 net33 VNW pm1p2_svt_lp W=590e-9 L=60e-9 MR=1
MPM3 net34 B1 VDD VNW pm1p2_svt_lp W=590e-9 L=60e-9 MR=1
MPM2 net25 B0 net34 VNW pm1p2_svt_lp W=590e-9 L=60e-9 MR=1
MPM1 net35 A1 VDD VNW pm1p2_svt_lp W=590e-9 L=60e-9 MR=1
MPM0 net25 A0 net35 VNW pm1p2_svt_lp W=590e-9 L=60e-9 MR=1
.ENDS
.SUBCKT OA222X4_9TSVT A0 A1 B0 B1 C0 C1 VDD VSS Y VNW VPW
MNM6 Y net25 VSS VPW nm1p2_svt_lp W=1.88e-6 L=60e-9 MR=1
MNM5 net19 C1 VSS VPW nm1p2_svt_lp W=940e-9 L=60e-9 MR=1
MNM4 net19 C0 VSS VPW nm1p2_svt_lp W=940e-9 L=60e-9 MR=1
MNM3 net20 B1 net19 VPW nm1p2_svt_lp W=940e-9 L=60e-9 MR=1
MNM2 net20 B0 net19 VPW nm1p2_svt_lp W=940e-9 L=60e-9 MR=1
MNM1 net25 A1 net20 VPW nm1p2_svt_lp W=940e-9 L=60e-9 MR=1
MNM0 net25 A0 net20 VPW nm1p2_svt_lp W=940e-9 L=60e-9 MR=1
MPM6 Y net25 VDD VNW pm1p2_svt_lp W=2.36e-6 L=60e-9 MR=1
MPM5 net33 C1 VDD VNW pm1p2_svt_lp W=1.18e-6 L=60e-9 MR=1
MPM4 net25 C0 net33 VNW pm1p2_svt_lp W=1.18e-6 L=60e-9 MR=1
MPM3 net34 B1 VDD VNW pm1p2_svt_lp W=1.18e-6 L=60e-9 MR=1
MPM2 net25 B0 net34 VNW pm1p2_svt_lp W=1.18e-6 L=60e-9 MR=1
MPM1 net35 A1 VDD VNW pm1p2_svt_lp W=1.18e-6 L=60e-9 MR=1
MPM0 net25 A0 net35 VNW pm1p2_svt_lp W=1.18e-6 L=60e-9 MR=1
.ENDS
.SUBCKT OA22X0P5_9TSVT A0 A1 B0 B1 VDD VSS Y VNW VPW
MNM4 Y net19 VSS VPW nm1p2_svt_lp W=230e-9 L=60e-9 MR=1
MNM3 net15 B1 VSS VPW nm1p2_svt_lp W=230e-9 L=60e-9 MR=1
MNM2 net15 B0 VSS VPW nm1p2_svt_lp W=230e-9 L=60e-9 MR=1
MNM1 net19 A1 net15 VPW nm1p2_svt_lp W=230e-9 L=60e-9 MR=1
MNM0 net19 A0 net15 VPW nm1p2_svt_lp W=230e-9 L=60e-9 MR=1
MPM4 Y net19 VDD VNW pm1p2_svt_lp W=300e-9 L=60e-9 MR=1
MPM3 net25 B1 VDD VNW pm1p2_svt_lp W=300e-9 L=60e-9 MR=1
MPM2 net19 B0 net25 VNW pm1p2_svt_lp W=300e-9 L=60e-9 MR=1
MPM1 net26 A1 VDD VNW pm1p2_svt_lp W=300e-9 L=60e-9 MR=1
MPM0 net19 A0 net26 VNW pm1p2_svt_lp W=300e-9 L=60e-9 MR=1
.ENDS
.SUBCKT OA22X1_9TSVT A0 A1 B0 B1 VDD VSS Y VNW VPW
MNM4 Y net19 VSS VPW nm1p2_svt_lp W=470e-9 L=60e-9 MR=1
MNM3 net15 B1 VSS VPW nm1p2_svt_lp W=470e-9 L=60e-9 MR=1
MNM2 net15 B0 VSS VPW nm1p2_svt_lp W=470e-9 L=60e-9 MR=1
MNM1 net19 A1 net15 VPW nm1p2_svt_lp W=470e-9 L=60e-9 MR=1
MNM0 net19 A0 net15 VPW nm1p2_svt_lp W=470e-9 L=60e-9 MR=1
MPM4 Y net19 VDD VNW pm1p2_svt_lp W=590e-9 L=60e-9 MR=1
MPM3 net25 B1 VDD VNW pm1p2_svt_lp W=590e-9 L=60e-9 MR=1
MPM2 net19 B0 net25 VNW pm1p2_svt_lp W=590e-9 L=60e-9 MR=1
MPM1 net26 A1 VDD VNW pm1p2_svt_lp W=590e-9 L=60e-9 MR=1
MPM0 net19 A0 net26 VNW pm1p2_svt_lp W=590e-9 L=60e-9 MR=1
.ENDS
.SUBCKT OA22X2_9TSVT A0 A1 B0 B1 VDD VSS Y VNW VPW
MNM4 Y net19 VSS VPW nm1p2_svt_lp W=940e-9 L=60e-9 MR=1
MNM3 net15 B1 VSS VPW nm1p2_svt_lp W=470e-9 L=60e-9 MR=1
MNM2 net15 B0 VSS VPW nm1p2_svt_lp W=470e-9 L=60e-9 MR=1
MNM1 net19 A1 net15 VPW nm1p2_svt_lp W=470e-9 L=60e-9 MR=1
MNM0 net19 A0 net15 VPW nm1p2_svt_lp W=470e-9 L=60e-9 MR=1
MPM4 Y net19 VDD VNW pm1p2_svt_lp W=1.18e-6 L=60e-9 MR=1
MPM3 net25 B1 VDD VNW pm1p2_svt_lp W=590e-9 L=60e-9 MR=1
MPM2 net19 B0 net25 VNW pm1p2_svt_lp W=590e-9 L=60e-9 MR=1
MPM1 net26 A1 VDD VNW pm1p2_svt_lp W=590e-9 L=60e-9 MR=1
MPM0 net19 A0 net26 VNW pm1p2_svt_lp W=590e-9 L=60e-9 MR=1
.ENDS
.SUBCKT OA22X4_9TSVT A0 A1 B0 B1 VDD VSS Y VNW VPW
MNM4 Y net19 VSS VPW nm1p2_svt_lp W=1.88e-6 L=60e-9 MR=1
MNM3 net15 B1 VSS VPW nm1p2_svt_lp W=940e-9 L=60e-9 MR=1
MNM2 net15 B0 VSS VPW nm1p2_svt_lp W=940e-9 L=60e-9 MR=1
MNM1 net19 A1 net15 VPW nm1p2_svt_lp W=940e-9 L=60e-9 MR=1
MNM0 net19 A0 net15 VPW nm1p2_svt_lp W=940e-9 L=60e-9 MR=1
MPM4 Y net19 VDD VNW pm1p2_svt_lp W=2.36e-6 L=60e-9 MR=1
MPM3 net25 B1 VDD VNW pm1p2_svt_lp W=1.18e-6 L=60e-9 MR=1
MPM2 net19 B0 net25 VNW pm1p2_svt_lp W=1.18e-6 L=60e-9 MR=1
MPM1 net26 A1 VDD VNW pm1p2_svt_lp W=1.18e-6 L=60e-9 MR=1
MPM0 net19 A0 net26 VNW pm1p2_svt_lp W=1.18e-6 L=60e-9 MR=1
.ENDS
.SUBCKT OA31X0P5_9TSVT A0 A1 A2 B0 VDD VSS Y VNW VPW
MNM4 Y net19 VSS VPW nm1p2_svt_lp W=230e-9 L=60e-9 MR=1
MNM3 net15 B0 VSS VPW nm1p2_svt_lp W=230e-9 L=60e-9 MR=1
MNM2 net19 A2 net15 VPW nm1p2_svt_lp W=230e-9 L=60e-9 MR=1
MNM1 net19 A1 net15 VPW nm1p2_svt_lp W=230e-9 L=60e-9 MR=1
MNM0 net19 A0 net15 VPW nm1p2_svt_lp W=230e-9 L=60e-9 MR=1
MPM4 Y net19 VDD VNW pm1p2_svt_lp W=300e-9 L=60e-9 MR=1
MPM3 net19 B0 VDD VNW pm1p2_svt_lp W=300e-9 L=60e-9 MR=1
MPM2 net26 A2 VDD VNW pm1p2_svt_lp W=300e-9 L=60e-9 MR=1
MPM1 net27 A1 net26 VNW pm1p2_svt_lp W=300e-9 L=60e-9 MR=1
MPM0 net19 A0 net27 VNW pm1p2_svt_lp W=300e-9 L=60e-9 MR=1
.ENDS
.SUBCKT OA31X1_9TSVT A0 A1 A2 B0 VDD VSS Y VNW VPW
MNM4 Y net19 VSS VPW nm1p2_svt_lp W=470e-9 L=60e-9 MR=1
MNM3 net15 B0 VSS VPW nm1p2_svt_lp W=470e-9 L=60e-9 MR=1
MNM2 net19 A2 net15 VPW nm1p2_svt_lp W=470e-9 L=60e-9 MR=1
MNM1 net19 A1 net15 VPW nm1p2_svt_lp W=470e-9 L=60e-9 MR=1
MNM0 net19 A0 net15 VPW nm1p2_svt_lp W=470e-9 L=60e-9 MR=1
MPM4 Y net19 VDD VNW pm1p2_svt_lp W=590e-9 L=60e-9 MR=1
MPM3 net19 B0 VDD VNW pm1p2_svt_lp W=590e-9 L=60e-9 MR=1
MPM2 net26 A2 VDD VNW pm1p2_svt_lp W=590e-9 L=60e-9 MR=1
MPM1 net27 A1 net26 VNW pm1p2_svt_lp W=590e-9 L=60e-9 MR=1
MPM0 net19 A0 net27 VNW pm1p2_svt_lp W=590e-9 L=60e-9 MR=1
.ENDS
.SUBCKT OA31X2_9TSVT A0 A1 A2 B0 VDD VSS Y VNW VPW
MNM4 Y net19 VSS VPW nm1p2_svt_lp W=940e-9 L=60e-9 MR=1
MNM3 net15 B0 VSS VPW nm1p2_svt_lp W=470e-9 L=60e-9 MR=1
MNM2 net19 A2 net15 VPW nm1p2_svt_lp W=470e-9 L=60e-9 MR=1
MNM1 net19 A1 net15 VPW nm1p2_svt_lp W=470e-9 L=60e-9 MR=1
MNM0 net19 A0 net15 VPW nm1p2_svt_lp W=470e-9 L=60e-9 MR=1
MPM4 Y net19 VDD VNW pm1p2_svt_lp W=1.18e-6 L=60e-9 MR=1
MPM3 net19 B0 VDD VNW pm1p2_svt_lp W=590e-9 L=60e-9 MR=1
MPM2 net26 A2 VDD VNW pm1p2_svt_lp W=590e-9 L=60e-9 MR=1
MPM1 net27 A1 net26 VNW pm1p2_svt_lp W=590e-9 L=60e-9 MR=1
MPM0 net19 A0 net27 VNW pm1p2_svt_lp W=590e-9 L=60e-9 MR=1
.ENDS
.SUBCKT OA31X4_9TSVT A0 A1 A2 B0 VDD VSS Y VNW VPW
MNM4 Y net19 VSS VPW nm1p2_svt_lp W=1.88e-6 L=60e-9 MR=1
MNM3 net15 B0 VSS VPW nm1p2_svt_lp W=940e-9 L=60e-9 MR=1
MNM2 net19 A2 net15 VPW nm1p2_svt_lp W=940e-9 L=60e-9 MR=1
MNM1 net19 A1 net15 VPW nm1p2_svt_lp W=940e-9 L=60e-9 MR=1
MNM0 net19 A0 net15 VPW nm1p2_svt_lp W=940e-9 L=60e-9 MR=1
MPM4 Y net19 VDD VNW pm1p2_svt_lp W=2.36e-6 L=60e-9 MR=1
MPM3 net19 B0 VDD VNW pm1p2_svt_lp W=1.18e-6 L=60e-9 MR=1
MPM2 net26 A2 VDD VNW pm1p2_svt_lp W=1.18e-6 L=60e-9 MR=1
MPM1 net27 A1 net26 VNW pm1p2_svt_lp W=1.18e-6 L=60e-9 MR=1
MPM0 net19 A0 net27 VNW pm1p2_svt_lp W=1.18e-6 L=60e-9 MR=1
.ENDS
.SUBCKT OA32X0P5_9TSVT A0 A1 A2 B0 B1 VDD VSS Y VNW VPW
MNM5 Y net21 VSS VPW nm1p2_svt_lp W=230e-9 L=60e-9 MR=1
MNM4 net17 B1 VSS VPW nm1p2_svt_lp W=230e-9 L=60e-9 MR=1
MNM3 net17 B0 VSS VPW nm1p2_svt_lp W=230e-9 L=60e-9 MR=1
MNM2 net21 A2 net17 VPW nm1p2_svt_lp W=230e-9 L=60e-9 MR=1
MNM1 net21 A1 net17 VPW nm1p2_svt_lp W=230e-9 L=60e-9 MR=1
MNM0 net21 A0 net17 VPW nm1p2_svt_lp W=230e-9 L=60e-9 MR=1
MPM5 Y net21 VDD VNW pm1p2_svt_lp W=300e-9 L=60e-9 MR=1
MPM4 net28 B1 VDD VNW pm1p2_svt_lp W=300e-9 L=60e-9 MR=1
MPM3 net21 B0 net28 VNW pm1p2_svt_lp W=300e-9 L=60e-9 MR=1
MPM2 net29 A2 VDD VNW pm1p2_svt_lp W=300e-9 L=60e-9 MR=1
MPM1 net30 A1 net29 VNW pm1p2_svt_lp W=300e-9 L=60e-9 MR=1
MPM0 net21 A0 net30 VNW pm1p2_svt_lp W=300e-9 L=60e-9 MR=1
.ENDS
.SUBCKT OA32X1_9TSVT A0 A1 A2 B0 B1 VDD VSS Y VNW VPW
MNM5 Y net21 VSS VPW nm1p2_svt_lp W=470e-9 L=60e-9 MR=1
MNM4 net17 B1 VSS VPW nm1p2_svt_lp W=470e-9 L=60e-9 MR=1
MNM3 net17 B0 VSS VPW nm1p2_svt_lp W=470e-9 L=60e-9 MR=1
MNM2 net21 A2 net17 VPW nm1p2_svt_lp W=470e-9 L=60e-9 MR=1
MNM1 net21 A1 net17 VPW nm1p2_svt_lp W=470e-9 L=60e-9 MR=1
MNM0 net21 A0 net17 VPW nm1p2_svt_lp W=470e-9 L=60e-9 MR=1
MPM5 Y net21 VDD VNW pm1p2_svt_lp W=590e-9 L=60e-9 MR=1
MPM4 net28 B1 VDD VNW pm1p2_svt_lp W=590e-9 L=60e-9 MR=1
MPM3 net21 B0 net28 VNW pm1p2_svt_lp W=590e-9 L=60e-9 MR=1
MPM2 net29 A2 VDD VNW pm1p2_svt_lp W=590e-9 L=60e-9 MR=1
MPM1 net30 A1 net29 VNW pm1p2_svt_lp W=590e-9 L=60e-9 MR=1
MPM0 net21 A0 net30 VNW pm1p2_svt_lp W=590e-9 L=60e-9 MR=1
.ENDS
.SUBCKT OA32X2_9TSVT A0 A1 A2 B0 B1 VDD VSS Y VNW VPW
MNM5 Y net21 VSS VPW nm1p2_svt_lp W=940e-9 L=60e-9 MR=1
MNM4 net17 B1 VSS VPW nm1p2_svt_lp W=470e-9 L=60e-9 MR=1
MNM3 net17 B0 VSS VPW nm1p2_svt_lp W=470e-9 L=60e-9 MR=1
MNM2 net21 A2 net17 VPW nm1p2_svt_lp W=470e-9 L=60e-9 MR=1
MNM1 net21 A1 net17 VPW nm1p2_svt_lp W=470e-9 L=60e-9 MR=1
MNM0 net21 A0 net17 VPW nm1p2_svt_lp W=470e-9 L=60e-9 MR=1
MPM5 Y net21 VDD VNW pm1p2_svt_lp W=1.18e-6 L=60e-9 MR=1
MPM4 net28 B1 VDD VNW pm1p2_svt_lp W=590e-9 L=60e-9 MR=1
MPM3 net21 B0 net28 VNW pm1p2_svt_lp W=590e-9 L=60e-9 MR=1
MPM2 net29 A2 VDD VNW pm1p2_svt_lp W=590e-9 L=60e-9 MR=1
MPM1 net30 A1 net29 VNW pm1p2_svt_lp W=590e-9 L=60e-9 MR=1
MPM0 net21 A0 net30 VNW pm1p2_svt_lp W=590e-9 L=60e-9 MR=1
.ENDS
.SUBCKT OA32X4_9TSVT A0 A1 A2 B0 B1 VDD VSS Y VNW VPW
MNM5 Y net21 VSS VPW nm1p2_svt_lp W=1.88e-6 L=60e-9 MR=1
MNM4 net17 B1 VSS VPW nm1p2_svt_lp W=940e-9 L=60e-9 MR=1
MNM3 net17 B0 VSS VPW nm1p2_svt_lp W=940e-9 L=60e-9 MR=1
MNM2 net21 A2 net17 VPW nm1p2_svt_lp W=940e-9 L=60e-9 MR=1
MNM1 net21 A1 net17 VPW nm1p2_svt_lp W=940e-9 L=60e-9 MR=1
MNM0 net21 A0 net17 VPW nm1p2_svt_lp W=940e-9 L=60e-9 MR=1
MPM5 Y net21 VDD VNW pm1p2_svt_lp W=2.36e-6 L=60e-9 MR=1
MPM4 net28 B1 VDD VNW pm1p2_svt_lp W=1.18e-6 L=60e-9 MR=1
MPM3 net21 B0 net28 VNW pm1p2_svt_lp W=1.18e-6 L=60e-9 MR=1
MPM2 net29 A2 VDD VNW pm1p2_svt_lp W=1.18e-6 L=60e-9 MR=1
MPM1 net30 A1 net29 VNW pm1p2_svt_lp W=1.18e-6 L=60e-9 MR=1
MPM0 net21 A0 net30 VNW pm1p2_svt_lp W=1.18e-6 L=60e-9 MR=1
.ENDS
.SUBCKT OA33X0P5_9TSVT A0 A1 A2 B0 B1 B2 VDD VSS Y VNW VPW
MNM6 Y net23 VSS VPW nm1p2_svt_lp W=230e-9 L=60e-9 MR=1
MNM5 net19 B2 VSS VPW nm1p2_svt_lp W=230e-9 L=60e-9 MR=1
MNM4 net19 B1 VSS VPW nm1p2_svt_lp W=230e-9 L=60e-9 MR=1
MNM3 net19 B0 VSS VPW nm1p2_svt_lp W=230e-9 L=60e-9 MR=1
MNM2 net23 A2 net19 VPW nm1p2_svt_lp W=230e-9 L=60e-9 MR=1
MNM1 net23 A1 net19 VPW nm1p2_svt_lp W=230e-9 L=60e-9 MR=1
MNM0 net23 A0 net19 VPW nm1p2_svt_lp W=230e-9 L=60e-9 MR=1
MPM6 Y net23 VDD VNW pm1p2_svt_lp W=300e-9 L=60e-9 MR=1
MPM5 net31 B2 VDD VNW pm1p2_svt_lp W=300e-9 L=60e-9 MR=1
MPM4 net32 B1 net31 VNW pm1p2_svt_lp W=300e-9 L=60e-9 MR=1
MPM3 net23 B0 net32 VNW pm1p2_svt_lp W=300e-9 L=60e-9 MR=1
MPM2 net33 A2 VDD VNW pm1p2_svt_lp W=300e-9 L=60e-9 MR=1
MPM1 net34 A1 net33 VNW pm1p2_svt_lp W=300e-9 L=60e-9 MR=1
MPM0 net23 A0 net34 VNW pm1p2_svt_lp W=300e-9 L=60e-9 MR=1
.ENDS
.SUBCKT OA33X1_9TSVT A0 A1 A2 B0 B1 B2 VDD VSS Y VNW VPW
MNM6 Y net23 VSS VPW nm1p2_svt_lp W=470e-9 L=60e-9 MR=1
MNM5 net19 B2 VSS VPW nm1p2_svt_lp W=470e-9 L=60e-9 MR=1
MNM4 net19 B1 VSS VPW nm1p2_svt_lp W=470e-9 L=60e-9 MR=1
MNM3 net19 B0 VSS VPW nm1p2_svt_lp W=470e-9 L=60e-9 MR=1
MNM2 net23 A2 net19 VPW nm1p2_svt_lp W=470e-9 L=60e-9 MR=1
MNM1 net23 A1 net19 VPW nm1p2_svt_lp W=470e-9 L=60e-9 MR=1
MNM0 net23 A0 net19 VPW nm1p2_svt_lp W=470e-9 L=60e-9 MR=1
MPM6 Y net23 VDD VNW pm1p2_svt_lp W=590e-9 L=60e-9 MR=1
MPM5 net31 B2 VDD VNW pm1p2_svt_lp W=590e-9 L=60e-9 MR=1
MPM4 net32 B1 net31 VNW pm1p2_svt_lp W=590e-9 L=60e-9 MR=1
MPM3 net23 B0 net32 VNW pm1p2_svt_lp W=590e-9 L=60e-9 MR=1
MPM2 net33 A2 VDD VNW pm1p2_svt_lp W=590e-9 L=60e-9 MR=1
MPM1 net34 A1 net33 VNW pm1p2_svt_lp W=590e-9 L=60e-9 MR=1
MPM0 net23 A0 net34 VNW pm1p2_svt_lp W=590e-9 L=60e-9 MR=1
.ENDS
.SUBCKT OA33X2_9TSVT A0 A1 A2 B0 B1 B2 VDD VSS Y VNW VPW
MNM6 Y net23 VSS VPW nm1p2_svt_lp W=940e-9 L=60e-9 MR=1
MNM5 net19 B2 VSS VPW nm1p2_svt_lp W=470e-9 L=60e-9 MR=1
MNM4 net19 B1 VSS VPW nm1p2_svt_lp W=470e-9 L=60e-9 MR=1
MNM3 net19 B0 VSS VPW nm1p2_svt_lp W=470e-9 L=60e-9 MR=1
MNM2 net23 A2 net19 VPW nm1p2_svt_lp W=470e-9 L=60e-9 MR=1
MNM1 net23 A1 net19 VPW nm1p2_svt_lp W=470e-9 L=60e-9 MR=1
MNM0 net23 A0 net19 VPW nm1p2_svt_lp W=470e-9 L=60e-9 MR=1
MPM6 Y net23 VDD VNW pm1p2_svt_lp W=1.18e-6 L=60e-9 MR=1
MPM5 net31 B2 VDD VNW pm1p2_svt_lp W=590e-9 L=60e-9 MR=1
MPM4 net32 B1 net31 VNW pm1p2_svt_lp W=590e-9 L=60e-9 MR=1
MPM3 net23 B0 net32 VNW pm1p2_svt_lp W=590e-9 L=60e-9 MR=1
MPM2 net33 A2 VDD VNW pm1p2_svt_lp W=590e-9 L=60e-9 MR=1
MPM1 net34 A1 net33 VNW pm1p2_svt_lp W=590e-9 L=60e-9 MR=1
MPM0 net23 A0 net34 VNW pm1p2_svt_lp W=590e-9 L=60e-9 MR=1
.ENDS
.SUBCKT OA33X4_9TSVT A0 A1 A2 B0 B1 B2 VDD VSS Y VNW VPW
MNM6 Y net23 VSS VPW nm1p2_svt_lp W=1.88e-6 L=60e-9 MR=1
MNM5 net19 B2 VSS VPW nm1p2_svt_lp W=940e-9 L=60e-9 MR=1
MNM4 net19 B1 VSS VPW nm1p2_svt_lp W=940e-9 L=60e-9 MR=1
MNM3 net19 B0 VSS VPW nm1p2_svt_lp W=940e-9 L=60e-9 MR=1
MNM2 net23 A2 net19 VPW nm1p2_svt_lp W=940e-9 L=60e-9 MR=1
MNM1 net23 A1 net19 VPW nm1p2_svt_lp W=940e-9 L=60e-9 MR=1
MNM0 net23 A0 net19 VPW nm1p2_svt_lp W=940e-9 L=60e-9 MR=1
MPM6 Y net23 VDD VNW pm1p2_svt_lp W=2.36e-6 L=60e-9 MR=1
MPM5 net31 B2 VDD VNW pm1p2_svt_lp W=1.18e-6 L=60e-9 MR=1
MPM4 net32 B1 net31 VNW pm1p2_svt_lp W=1.18e-6 L=60e-9 MR=1
MPM3 net23 B0 net32 VNW pm1p2_svt_lp W=1.18e-6 L=60e-9 MR=1
MPM2 net33 A2 VDD VNW pm1p2_svt_lp W=1.18e-6 L=60e-9 MR=1
MPM1 net34 A1 net33 VNW pm1p2_svt_lp W=1.18e-6 L=60e-9 MR=1
MPM0 net23 A0 net34 VNW pm1p2_svt_lp W=1.18e-6 L=60e-9 MR=1
.ENDS
.SUBCKT OAI211X0P5_9TSVT A0 A1 B0 C0 VDD VSS Y VNW VPW
MNM3 net22 C0 VSS VPW nm1p2_svt_lp W=230e-9 L=60e-9 MR=1
MNM2 net15 B0 net22 VPW nm1p2_svt_lp W=230e-9 L=60e-9 MR=1
MNM1 Y A1 net15 VPW nm1p2_svt_lp W=230e-9 L=60e-9 MR=1
MNM0 Y A0 net15 VPW nm1p2_svt_lp W=230e-9 L=60e-9 MR=1
MPM3 Y C0 VDD VNW pm1p2_svt_lp W=300e-9 L=60e-9 MR=1
MPM2 Y B0 VDD VNW pm1p2_svt_lp W=300e-9 L=60e-9 MR=1
MPM1 net23 A1 VDD VNW pm1p2_svt_lp W=300e-9 L=60e-9 MR=1
MPM0 Y A0 net23 VNW pm1p2_svt_lp W=300e-9 L=60e-9 MR=1
.ENDS
.SUBCKT OAI211X1_9TSVT A0 A1 B0 C0 VDD VSS Y VNW VPW
MNM3 net22 C0 VSS VPW nm1p2_svt_lp W=470e-9 L=60e-9 MR=1
MNM2 net15 B0 net22 VPW nm1p2_svt_lp W=470e-9 L=60e-9 MR=1
MNM1 Y A1 net15 VPW nm1p2_svt_lp W=470e-9 L=60e-9 MR=1
MNM0 Y A0 net15 VPW nm1p2_svt_lp W=470e-9 L=60e-9 MR=1
MPM3 Y C0 VDD VNW pm1p2_svt_lp W=590e-9 L=60e-9 MR=1
MPM2 Y B0 VDD VNW pm1p2_svt_lp W=590e-9 L=60e-9 MR=1
MPM1 net23 A1 VDD VNW pm1p2_svt_lp W=590e-9 L=60e-9 MR=1
MPM0 Y A0 net23 VNW pm1p2_svt_lp W=590e-9 L=60e-9 MR=1
.ENDS
.SUBCKT OAI211X2_9TSVT A0 A1 B0 C0 VDD VSS Y VNW VPW
MNM3 net22 C0 VSS VPW nm1p2_svt_lp W=940e-9 L=60e-9 MR=1
MNM2 net15 B0 net22 VPW nm1p2_svt_lp W=940e-9 L=60e-9 MR=1
MNM1 Y A1 net15 VPW nm1p2_svt_lp W=940e-9 L=60e-9 MR=1
MNM0 Y A0 net15 VPW nm1p2_svt_lp W=940e-9 L=60e-9 MR=1
MPM3 Y C0 VDD VNW pm1p2_svt_lp W=1.18e-6 L=60e-9 MR=1
MPM2 Y B0 VDD VNW pm1p2_svt_lp W=1.18e-6 L=60e-9 MR=1
MPM1 net23 A1 VDD VNW pm1p2_svt_lp W=1.18e-6 L=60e-9 MR=1
MPM0 Y A0 net23 VNW pm1p2_svt_lp W=1.18e-6 L=60e-9 MR=1
.ENDS
.SUBCKT OAI211X4_9TSVT A0 A1 B0 C0 VDD VSS Y VNW VPW
MNM3 net22 C0 VSS VPW nm1p2_svt_lp W=1.88e-6 L=60e-9 MR=1
MNM2 net15 B0 net22 VPW nm1p2_svt_lp W=1.88e-6 L=60e-9 MR=1
MNM1 Y A1 net15 VPW nm1p2_svt_lp W=1.88e-6 L=60e-9 MR=1
MNM0 Y A0 net15 VPW nm1p2_svt_lp W=1.88e-6 L=60e-9 MR=1
MPM3 Y C0 VDD VNW pm1p2_svt_lp W=2.36e-6 L=60e-9 MR=1
MPM2 Y B0 VDD VNW pm1p2_svt_lp W=2.36e-6 L=60e-9 MR=1
MPM1 net23 A1 VDD VNW pm1p2_svt_lp W=2.36e-6 L=60e-9 MR=1
MPM0 Y A0 net23 VNW pm1p2_svt_lp W=2.36e-6 L=60e-9 MR=1
.ENDS
.SUBCKT OAI21BBX0P5_9TSVT AN0 AN1 B0 VDD VSS Y VNW VPW
MNM3 Y B0 net22 VPW nm1p2_svt_lp W=230e-9 L=60e-9 MR=1
MNM2 net22 net13 VSS VPW nm1p2_svt_lp W=230e-9 L=60e-9 MR=1
MNM1 net23 AN1 VSS VPW nm1p2_svt_lp W=230e-9 L=60e-9 MR=1
MNM0 net13 AN0 net23 VPW nm1p2_svt_lp W=230e-9 L=60e-9 MR=1
MPM3 Y B0 VDD VNW pm1p2_svt_lp W=300e-9 L=60e-9 MR=1
MPM2 Y net13 VDD VNW pm1p2_svt_lp W=300e-9 L=60e-9 MR=1
MPM1 net13 AN1 VDD VNW pm1p2_svt_lp W=300e-9 L=60e-9 MR=1
MPM0 net13 AN0 VDD VNW pm1p2_svt_lp W=300e-9 L=60e-9 MR=1
.ENDS
.SUBCKT OAI21BBX1_9TSVT AN0 AN1 B0 VDD VSS Y VNW VPW
MNM3 Y B0 net22 VPW nm1p2_svt_lp W=470e-9 L=60e-9 MR=1
MNM2 net22 net13 VSS VPW nm1p2_svt_lp W=470e-9 L=60e-9 MR=1
MNM1 net23 AN1 VSS VPW nm1p2_svt_lp W=230n L=60n MR=1
MNM0 net13 AN0 net23 VPW nm1p2_svt_lp W=230n L=60n MR=1
MPM3 Y B0 VDD VNW pm1p2_svt_lp W=590e-9 L=60e-9 MR=1
MPM2 Y net13 VDD VNW pm1p2_svt_lp W=590e-9 L=60e-9 MR=1
MPM1 net13 AN1 VDD VNW pm1p2_svt_lp W=300n L=60n MR=1
MPM0 net13 AN0 VDD VNW pm1p2_svt_lp W=300n L=60n MR=1
.ENDS
.SUBCKT OAI21BBX2_9TSVT AN0 AN1 B0 VDD VSS Y VNW VPW
MNM3 Y B0 net22 VPW nm1p2_svt_lp W=940e-9 L=60e-9 MR=1
MNM2 net22 net13 VSS VPW nm1p2_svt_lp W=940e-9 L=60e-9 MR=1
MNM1 net23 AN1 VSS VPW nm1p2_svt_lp W=470e-9 L=60e-9 MR=1
MNM0 net13 AN0 net23 VPW nm1p2_svt_lp W=470e-9 L=60e-9 MR=1
MPM3 Y B0 VDD VNW pm1p2_svt_lp W=1.18e-6 L=60e-9 MR=1
MPM2 Y net13 VDD VNW pm1p2_svt_lp W=1.18e-6 L=60e-9 MR=1
MPM1 net13 AN1 VDD VNW pm1p2_svt_lp W=590e-9 L=60e-9 MR=1
MPM0 net13 AN0 VDD VNW pm1p2_svt_lp W=590e-9 L=60e-9 MR=1
.ENDS
.SUBCKT OAI21BBX4_9TSVT AN0 AN1 B0 VDD VSS Y VNW VPW
MNM3 net019 B0 net22 VPW nm1p2_svt_lp W=470n L=60n MR=1
MNM2 net22 net13 VSS VPW nm1p2_svt_lp W=470n L=60n MR=1
MNM1 net23 AN1 VSS VPW nm1p2_svt_lp W=230n L=60n MR=1
MNM0 net13 AN0 net23 VPW nm1p2_svt_lp W=230n L=60n MR=1
MPM3 net019 B0 VDD VNW pm1p2_svt_lp W=590n L=60n MR=1
MPM2 net019 net13 VDD VNW pm1p2_svt_lp W=590n L=60n MR=1
MPM1 net13 AN1 VDD VNW pm1p2_svt_lp W=300n L=60n MR=1
MPM0 net13 AN0 VDD VNW pm1p2_svt_lp W=300n L=60n MR=1
MM3 Y net014 VSS VPW nm1p2_svt_lp W=1.88u L=60n MR=1
MM0 net014 net019 VSS VPW nm1p2_svt_lp W=940n L=60n MR=1
MM2 Y net014 VDD VNW pm1p2_svt_lp W=2.36u L=60n MR=1
MM1 net014 net019 VDD VNW pm1p2_svt_lp W=1.18u L=60n MR=1
.ENDS
.SUBCKT OAI21X0P5_9TSVT A0 A1 B0 VDD VSS Y VNW VPW
MNM2 net13 B0 VSS VPW nm1p2_svt_lp W=230e-9 L=60e-9 MR=1
MNM1 Y A1 net13 VPW nm1p2_svt_lp W=230e-9 L=60e-9 MR=1
MNM0 Y A0 net13 VPW nm1p2_svt_lp W=230e-9 L=60e-9 MR=1
MPM2 Y B0 VDD VNW pm1p2_svt_lp W=300e-9 L=60e-9 MR=1
MPM1 net19 A1 VDD VNW pm1p2_svt_lp W=300e-9 L=60e-9 MR=1
MPM0 Y A0 net19 VNW pm1p2_svt_lp W=300e-9 L=60e-9 MR=1
.ENDS
.SUBCKT OAI21X1_9TSVT A0 A1 B0 VDD VSS Y VNW VPW
MNM2 net13 B0 VSS VPW nm1p2_svt_lp W=470e-9 L=60e-9 MR=1
MNM1 Y A1 net13 VPW nm1p2_svt_lp W=470e-9 L=60e-9 MR=1
MNM0 Y A0 net13 VPW nm1p2_svt_lp W=470e-9 L=60e-9 MR=1
MPM2 Y B0 VDD VNW pm1p2_svt_lp W=590e-9 L=60e-9 MR=1
MPM1 net19 A1 VDD VNW pm1p2_svt_lp W=590e-9 L=60e-9 MR=1
MPM0 Y A0 net19 VNW pm1p2_svt_lp W=590e-9 L=60e-9 MR=1
.ENDS
.SUBCKT OAI21X2_9TSVT A0 A1 B0 VDD VSS Y VNW VPW
MNM2 net13 B0 VSS VPW nm1p2_svt_lp W=940e-9 L=60e-9 MR=1
MNM1 Y A1 net13 VPW nm1p2_svt_lp W=940e-9 L=60e-9 MR=1
MNM0 Y A0 net13 VPW nm1p2_svt_lp W=940e-9 L=60e-9 MR=1
MPM2 Y B0 VDD VNW pm1p2_svt_lp W=1.18e-6 L=60e-9 MR=1
MPM1 net19 A1 VDD VNW pm1p2_svt_lp W=1.18e-6 L=60e-9 MR=1
MPM0 Y A0 net19 VNW pm1p2_svt_lp W=1.18e-6 L=60e-9 MR=1
.ENDS
.SUBCKT OAI21X4_9TSVT A0 A1 B0 VDD VSS Y VNW VPW
MNM2 net13 B0 VSS VPW nm1p2_svt_lp W=1.88e-6 L=60e-9 MR=1
MNM1 Y A1 net13 VPW nm1p2_svt_lp W=1.88e-6 L=60e-9 MR=1
MNM0 Y A0 net13 VPW nm1p2_svt_lp W=1.88e-6 L=60e-9 MR=1
MPM2 Y B0 VDD VNW pm1p2_svt_lp W=2.36e-6 L=60e-9 MR=1
MPM1 net19 A1 VDD VNW pm1p2_svt_lp W=2.36e-6 L=60e-9 MR=1
MPM0 Y A0 net19 VNW pm1p2_svt_lp W=2.36e-6 L=60e-9 MR=1
.ENDS
.SUBCKT OAI221X0P5_9TSVT A0 A1 B0 B1 C0 VDD VSS Y VNW VPW
MNM4 net17 C0 VSS VPW nm1p2_svt_lp W=230e-9 L=60e-9 MR=1
MNM3 net18 B1 net17 VPW nm1p2_svt_lp W=230e-9 L=60e-9 MR=1
MNM2 net18 B0 net17 VPW nm1p2_svt_lp W=230e-9 L=60e-9 MR=1
MNM1 Y A1 net18 VPW nm1p2_svt_lp W=230e-9 L=60e-9 MR=1
MNM0 Y A0 net18 VPW nm1p2_svt_lp W=230e-9 L=60e-9 MR=1
MPM4 Y C0 VDD VNW pm1p2_svt_lp W=300e-9 L=60e-9 MR=1
MPM3 net27 B1 VDD VNW pm1p2_svt_lp W=300e-9 L=60e-9 MR=1
MPM2 Y B0 net27 VNW pm1p2_svt_lp W=300e-9 L=60e-9 MR=1
MPM1 net28 A1 VDD VNW pm1p2_svt_lp W=300e-9 L=60e-9 MR=1
MPM0 Y A0 net28 VNW pm1p2_svt_lp W=300e-9 L=60e-9 MR=1
.ENDS
.SUBCKT OAI221X1_9TSVT A0 A1 B0 B1 C0 VDD VSS Y VNW VPW
MNM4 net17 C0 VSS VPW nm1p2_svt_lp W=470e-9 L=60e-9 MR=1
MNM3 net18 B1 net17 VPW nm1p2_svt_lp W=470e-9 L=60e-9 MR=1
MNM2 net18 B0 net17 VPW nm1p2_svt_lp W=470e-9 L=60e-9 MR=1
MNM1 Y A1 net18 VPW nm1p2_svt_lp W=470e-9 L=60e-9 MR=1
MNM0 Y A0 net18 VPW nm1p2_svt_lp W=470e-9 L=60e-9 MR=1
MPM4 Y C0 VDD VNW pm1p2_svt_lp W=590e-9 L=60e-9 MR=1
MPM3 net27 B1 VDD VNW pm1p2_svt_lp W=590e-9 L=60e-9 MR=1
MPM2 Y B0 net27 VNW pm1p2_svt_lp W=590e-9 L=60e-9 MR=1
MPM1 net28 A1 VDD VNW pm1p2_svt_lp W=590e-9 L=60e-9 MR=1
MPM0 Y A0 net28 VNW pm1p2_svt_lp W=590e-9 L=60e-9 MR=1
.ENDS
.SUBCKT OAI221X2_9TSVT A0 A1 B0 B1 C0 VDD VSS Y VNW VPW
MNM4 net17 C0 VSS VPW nm1p2_svt_lp W=940e-9 L=60e-9 MR=1
MNM3 net18 B1 net17 VPW nm1p2_svt_lp W=940e-9 L=60e-9 MR=1
MNM2 net18 B0 net17 VPW nm1p2_svt_lp W=940e-9 L=60e-9 MR=1
MNM1 Y A1 net18 VPW nm1p2_svt_lp W=940e-9 L=60e-9 MR=1
MNM0 Y A0 net18 VPW nm1p2_svt_lp W=940e-9 L=60e-9 MR=1
MPM4 Y C0 VDD VNW pm1p2_svt_lp W=1.18e-6 L=60e-9 MR=1
MPM3 net27 B1 VDD VNW pm1p2_svt_lp W=1.18e-6 L=60e-9 MR=1
MPM2 Y B0 net27 VNW pm1p2_svt_lp W=1.18e-6 L=60e-9 MR=1
MPM1 net28 A1 VDD VNW pm1p2_svt_lp W=1.18e-6 L=60e-9 MR=1
MPM0 Y A0 net28 VNW pm1p2_svt_lp W=1.18e-6 L=60e-9 MR=1
.ENDS
.SUBCKT OAI221X4_9TSVT A0 A1 B0 B1 C0 VDD VSS Y VNW VPW
MNM4 net17 C0 VSS VPW nm1p2_svt_lp W=1.88e-6 L=60e-9 MR=1
MNM3 net18 B1 net17 VPW nm1p2_svt_lp W=1.88e-6 L=60e-9 MR=1
MNM2 net18 B0 net17 VPW nm1p2_svt_lp W=1.88e-6 L=60e-9 MR=1
MNM1 Y A1 net18 VPW nm1p2_svt_lp W=1.88e-6 L=60e-9 MR=1
MNM0 Y A0 net18 VPW nm1p2_svt_lp W=1.88e-6 L=60e-9 MR=1
MPM4 Y C0 VDD VNW pm1p2_svt_lp W=2.36e-6 L=60e-9 MR=1
MPM3 net27 B1 VDD VNW pm1p2_svt_lp W=2.36e-6 L=60e-9 MR=1
MPM2 Y B0 net27 VNW pm1p2_svt_lp W=2.36e-6 L=60e-9 MR=1
MPM1 net28 A1 VDD VNW pm1p2_svt_lp W=2.36e-6 L=60e-9 MR=1
MPM0 Y A0 net28 VNW pm1p2_svt_lp W=2.36e-6 L=60e-9 MR=1
.ENDS
.SUBCKT OAI222X0P5_9TSVT A0 A1 B0 B1 C0 C1 VDD VSS Y VNW VPW
MNM5 net19 C1 VSS VPW nm1p2_svt_lp W=230e-9 L=60e-9 MR=1
MNM4 net19 C0 VSS VPW nm1p2_svt_lp W=230e-9 L=60e-9 MR=1
MNM3 net20 B1 net19 VPW nm1p2_svt_lp W=230e-9 L=60e-9 MR=1
MNM2 net20 B0 net19 VPW nm1p2_svt_lp W=230e-9 L=60e-9 MR=1
MNM1 Y A1 net20 VPW nm1p2_svt_lp W=230e-9 L=60e-9 MR=1
MNM0 Y A0 net20 VPW nm1p2_svt_lp W=230e-9 L=60e-9 MR=1
MPM5 net30 C1 VDD VNW pm1p2_svt_lp W=300e-9 L=60e-9 MR=1
MPM4 Y C0 net30 VNW pm1p2_svt_lp W=300e-9 L=60e-9 MR=1
MPM3 net31 B1 VDD VNW pm1p2_svt_lp W=300e-9 L=60e-9 MR=1
MPM2 Y B0 net31 VNW pm1p2_svt_lp W=300e-9 L=60e-9 MR=1
MPM1 net32 A1 VDD VNW pm1p2_svt_lp W=300e-9 L=60e-9 MR=1
MPM0 Y A0 net32 VNW pm1p2_svt_lp W=300e-9 L=60e-9 MR=1
.ENDS
.SUBCKT OAI222X1_9TSVT A0 A1 B0 B1 C0 C1 VDD VSS Y VNW VPW
MNM5 net19 C1 VSS VPW nm1p2_svt_lp W=470e-9 L=60e-9 MR=1
MNM4 net19 C0 VSS VPW nm1p2_svt_lp W=470e-9 L=60e-9 MR=1
MNM3 net20 B1 net19 VPW nm1p2_svt_lp W=470e-9 L=60e-9 MR=1
MNM2 net20 B0 net19 VPW nm1p2_svt_lp W=470e-9 L=60e-9 MR=1
MNM1 Y A1 net20 VPW nm1p2_svt_lp W=470e-9 L=60e-9 MR=1
MNM0 Y A0 net20 VPW nm1p2_svt_lp W=470e-9 L=60e-9 MR=1
MPM5 net30 C1 VDD VNW pm1p2_svt_lp W=590e-9 L=60e-9 MR=1
MPM4 Y C0 net30 VNW pm1p2_svt_lp W=590e-9 L=60e-9 MR=1
MPM3 net31 B1 VDD VNW pm1p2_svt_lp W=590e-9 L=60e-9 MR=1
MPM2 Y B0 net31 VNW pm1p2_svt_lp W=590e-9 L=60e-9 MR=1
MPM1 net32 A1 VDD VNW pm1p2_svt_lp W=590e-9 L=60e-9 MR=1
MPM0 Y A0 net32 VNW pm1p2_svt_lp W=590e-9 L=60e-9 MR=1
.ENDS
.SUBCKT OAI222X2_9TSVT A0 A1 B0 B1 C0 C1 VDD VSS Y VNW VPW
MNM5 net19 C1 VSS VPW nm1p2_svt_lp W=940e-9 L=60e-9 MR=1
MNM4 net19 C0 VSS VPW nm1p2_svt_lp W=940e-9 L=60e-9 MR=1
MNM3 net20 B1 net19 VPW nm1p2_svt_lp W=940e-9 L=60e-9 MR=1
MNM2 net20 B0 net19 VPW nm1p2_svt_lp W=940e-9 L=60e-9 MR=1
MNM1 Y A1 net20 VPW nm1p2_svt_lp W=940e-9 L=60e-9 MR=1
MNM0 Y A0 net20 VPW nm1p2_svt_lp W=940e-9 L=60e-9 MR=1
MPM5 net30 C1 VDD VNW pm1p2_svt_lp W=1.18e-6 L=60e-9 MR=1
MPM4 Y C0 net30 VNW pm1p2_svt_lp W=1.18e-6 L=60e-9 MR=1
MPM3 net31 B1 VDD VNW pm1p2_svt_lp W=1.18e-6 L=60e-9 MR=1
MPM2 Y B0 net31 VNW pm1p2_svt_lp W=1.18e-6 L=60e-9 MR=1
MPM1 net32 A1 VDD VNW pm1p2_svt_lp W=1.18e-6 L=60e-9 MR=1
MPM0 Y A0 net32 VNW pm1p2_svt_lp W=1.18e-6 L=60e-9 MR=1
.ENDS
.SUBCKT OAI222X4_9TSVT A0 A1 B0 B1 C0 C1 VDD VSS Y VNW VPW
MNM5 net19 C1 VSS VPW nm1p2_svt_lp W=1.88e-6 L=60e-9 MR=1
MNM4 net19 C0 VSS VPW nm1p2_svt_lp W=1.88e-6 L=60e-9 MR=1
MNM3 net20 B1 net19 VPW nm1p2_svt_lp W=1.88e-6 L=60e-9 MR=1
MNM2 net20 B0 net19 VPW nm1p2_svt_lp W=1.88e-6 L=60e-9 MR=1
MNM1 Y A1 net20 VPW nm1p2_svt_lp W=1.88e-6 L=60e-9 MR=1
MNM0 Y A0 net20 VPW nm1p2_svt_lp W=1.88e-6 L=60e-9 MR=1
MPM5 net30 C1 VDD VNW pm1p2_svt_lp W=2.36e-6 L=60e-9 MR=1
MPM4 Y C0 net30 VNW pm1p2_svt_lp W=2.36e-6 L=60e-9 MR=1
MPM3 net31 B1 VDD VNW pm1p2_svt_lp W=2.36e-6 L=60e-9 MR=1
MPM2 Y B0 net31 VNW pm1p2_svt_lp W=2.36e-6 L=60e-9 MR=1
MPM1 net32 A1 VDD VNW pm1p2_svt_lp W=2.36e-6 L=60e-9 MR=1
MPM0 Y A0 net32 VNW pm1p2_svt_lp W=2.36e-6 L=60e-9 MR=1
.ENDS
.SUBCKT OAI22BBX0P5_9TSVT AN0 AN1 B0 B1 VDD VSS Y VNW VPW
MNM4 net24 B1 VSS VPW nm1p2_svt_lp W=230e-9 L=60e-9 MR=1
MNM3 net24 B0 VSS VPW nm1p2_svt_lp W=230e-9 L=60e-9 MR=1
MNM2 Y net15 net24 VPW nm1p2_svt_lp W=230e-9 L=60e-9 MR=1
MNM1 net29 AN1 VSS VPW nm1p2_svt_lp W=230e-9 L=60e-9 MR=1
MNM0 net15 AN0 net29 VPW nm1p2_svt_lp W=230e-9 L=60e-9 MR=1
MPM4 net28 B1 VDD VNW pm1p2_svt_lp W=300e-9 L=60e-9 MR=1
MPM3 Y B0 net28 VNW pm1p2_svt_lp W=300e-9 L=60e-9 MR=1
MPM2 Y net15 VDD VNW pm1p2_svt_lp W=300e-9 L=60e-9 MR=1
MPM1 net15 AN1 VDD VNW pm1p2_svt_lp W=300e-9 L=60e-9 MR=1
MPM0 net15 AN0 VDD VNW pm1p2_svt_lp W=300e-9 L=60e-9 MR=1
.ENDS
.SUBCKT OAI22BBX1_9TSVT AN0 AN1 B0 B1 VDD VSS Y VNW VPW
MNM4 net24 B1 VSS VPW nm1p2_svt_lp W=470e-9 L=60e-9 MR=1
MNM3 net24 B0 VSS VPW nm1p2_svt_lp W=470e-9 L=60e-9 MR=1
MNM2 Y net15 net24 VPW nm1p2_svt_lp W=470e-9 L=60e-9 MR=1
MNM1 net29 AN1 VSS VPW nm1p2_svt_lp W=230n L=60n MR=1
MNM0 net15 AN0 net29 VPW nm1p2_svt_lp W=230n L=60n MR=1
MPM4 net28 B1 VDD VNW pm1p2_svt_lp W=590e-9 L=60e-9 MR=1
MPM3 Y B0 net28 VNW pm1p2_svt_lp W=590e-9 L=60e-9 MR=1
MPM2 Y net15 VDD VNW pm1p2_svt_lp W=590e-9 L=60e-9 MR=1
MPM1 net15 AN1 VDD VNW pm1p2_svt_lp W=300n L=60n MR=1
MPM0 net15 AN0 VDD VNW pm1p2_svt_lp W=300n L=60n MR=1
.ENDS
.SUBCKT OAI22BBX2_9TSVT AN0 AN1 B0 B1 VDD VSS Y VNW VPW
MNM4 net24 B1 VSS VPW nm1p2_svt_lp W=940e-9 L=60e-9 MR=1
MNM3 net24 B0 VSS VPW nm1p2_svt_lp W=940e-9 L=60e-9 MR=1
MNM2 Y net15 net24 VPW nm1p2_svt_lp W=940e-9 L=60e-9 MR=1
MNM1 net29 AN1 VSS VPW nm1p2_svt_lp W=470e-9 L=60e-9 MR=1
MNM0 net15 AN0 net29 VPW nm1p2_svt_lp W=470e-9 L=60e-9 MR=1
MPM4 net28 B1 VDD VNW pm1p2_svt_lp W=1.18e-6 L=60e-9 MR=1
MPM3 Y B0 net28 VNW pm1p2_svt_lp W=1.18e-6 L=60e-9 MR=1
MPM2 Y net15 VDD VNW pm1p2_svt_lp W=1.18e-6 L=60e-9 MR=1
MPM1 net15 AN1 VDD VNW pm1p2_svt_lp W=590e-9 L=60e-9 MR=1
MPM0 net15 AN0 VDD VNW pm1p2_svt_lp W=590e-9 L=60e-9 MR=1
.ENDS
.SUBCKT OAI22BBX4_9TSVT AN0 AN1 B0 B1 VDD VSS Y VNW VPW
MNM4 net24 B1 VSS VPW nm1p2_svt_lp W=470n L=60n MR=1
MNM3 net24 B0 VSS VPW nm1p2_svt_lp W=470n L=60n MR=1
MNM2 net011 net15 net24 VPW nm1p2_svt_lp W=470n L=60n MR=1
MNM1 net29 AN1 VSS VPW nm1p2_svt_lp W=230n L=60n MR=1
MNM0 net15 AN0 net29 VPW nm1p2_svt_lp W=230n L=60n MR=1
MPM4 net28 B1 VDD VNW pm1p2_svt_lp W=590n L=60n MR=1
MPM3 net011 B0 net28 VNW pm1p2_svt_lp W=590n L=60n MR=1
MPM2 net011 net15 VDD VNW pm1p2_svt_lp W=590n L=60n MR=1
MPM1 net15 AN1 VDD VNW pm1p2_svt_lp W=300n L=60n MR=1
MPM0 net15 AN0 VDD VNW pm1p2_svt_lp W=300n L=60n MR=1
MM3 Y net016 VSS VPW nm1p2_svt_lp W=1.88u L=60n MR=1
MM0 net016 net011 VSS VPW nm1p2_svt_lp W=940n L=60n MR=1
MM2 Y net016 VDD VNW pm1p2_svt_lp W=2.36u L=60n MR=1
MM1 net016 net011 VDD VNW pm1p2_svt_lp W=1.18u L=60n MR=1
.ENDS
.SUBCKT OAI22X0P5_9TSVT A0 A1 B0 B1 VDD VSS Y VNW VPW
MNM3 net15 B1 VSS VPW nm1p2_svt_lp W=230e-9 L=60e-9 MR=1
MNM2 net15 B0 VSS VPW nm1p2_svt_lp W=230e-9 L=60e-9 MR=1
MNM1 Y A1 net15 VPW nm1p2_svt_lp W=230e-9 L=60e-9 MR=1
MNM0 Y A0 net15 VPW nm1p2_svt_lp W=230e-9 L=60e-9 MR=1
MPM3 net22 B1 VDD VNW pm1p2_svt_lp W=300e-9 L=60e-9 MR=1
MPM2 Y B0 net22 VNW pm1p2_svt_lp W=300e-9 L=60e-9 MR=1
MPM1 net23 A1 VDD VNW pm1p2_svt_lp W=300e-9 L=60e-9 MR=1
MPM0 Y A0 net23 VNW pm1p2_svt_lp W=300e-9 L=60e-9 MR=1
.ENDS
.SUBCKT OAI22X1_9TSVT A0 A1 B0 B1 VDD VSS Y VNW VPW
MNM3 net15 B1 VSS VPW nm1p2_svt_lp W=470e-9 L=60e-9 MR=1
MNM2 net15 B0 VSS VPW nm1p2_svt_lp W=470e-9 L=60e-9 MR=1
MNM1 Y A1 net15 VPW nm1p2_svt_lp W=470e-9 L=60e-9 MR=1
MNM0 Y A0 net15 VPW nm1p2_svt_lp W=470e-9 L=60e-9 MR=1
MPM3 net22 B1 VDD VNW pm1p2_svt_lp W=590e-9 L=60e-9 MR=1
MPM2 Y B0 net22 VNW pm1p2_svt_lp W=590e-9 L=60e-9 MR=1
MPM1 net23 A1 VDD VNW pm1p2_svt_lp W=590e-9 L=60e-9 MR=1
MPM0 Y A0 net23 VNW pm1p2_svt_lp W=590e-9 L=60e-9 MR=1
.ENDS
.SUBCKT OAI22X2_9TSVT A0 A1 B0 B1 VDD VSS Y VNW VPW
MNM3 net15 B1 VSS VPW nm1p2_svt_lp W=940e-9 L=60e-9 MR=1
MNM2 net15 B0 VSS VPW nm1p2_svt_lp W=940e-9 L=60e-9 MR=1
MNM1 Y A1 net15 VPW nm1p2_svt_lp W=940e-9 L=60e-9 MR=1
MNM0 Y A0 net15 VPW nm1p2_svt_lp W=940e-9 L=60e-9 MR=1
MPM3 net22 B1 VDD VNW pm1p2_svt_lp W=1.18e-6 L=60e-9 MR=1
MPM2 Y B0 net22 VNW pm1p2_svt_lp W=1.18e-6 L=60e-9 MR=1
MPM1 net23 A1 VDD VNW pm1p2_svt_lp W=1.18e-6 L=60e-9 MR=1
MPM0 Y A0 net23 VNW pm1p2_svt_lp W=1.18e-6 L=60e-9 MR=1
.ENDS
.SUBCKT OAI22X4_9TSVT A0 A1 B0 B1 VDD VSS Y VNW VPW
MNM3 net15 B1 VSS VPW nm1p2_svt_lp W=470n L=60n MR=1
MNM2 net15 B0 VSS VPW nm1p2_svt_lp W=470n L=60n MR=1
MNM1 net012 A1 net15 VPW nm1p2_svt_lp W=470n L=60n MR=1
MNM0 net012 A0 net15 VPW nm1p2_svt_lp W=470n L=60n MR=1
MPM3 net22 B1 VDD VNW pm1p2_svt_lp W=590n L=60n MR=1
MPM2 net012 B0 net22 VNW pm1p2_svt_lp W=590n L=60n MR=1
MPM1 net23 A1 VDD VNW pm1p2_svt_lp W=590n L=60n MR=1
MPM0 net012 A0 net23 VNW pm1p2_svt_lp W=590n L=60n MR=1
MM3 Y net015 VSS VPW nm1p2_svt_lp W=1.88u L=60n MR=1
MM0 net015 net012 VSS VPW nm1p2_svt_lp W=940n L=60n MR=1
MM2 Y net015 VDD VNW pm1p2_svt_lp W=2.36u L=60n MR=1
MM1 net015 net012 VDD VNW pm1p2_svt_lp W=1.18u L=60n MR=1
.ENDS
.SUBCKT OAI31X0P5_9TSVT A0 A1 A2 B0 VDD VSS Y VNW VPW
MNM3 net15 B0 VSS VPW nm1p2_svt_lp W=230e-9 L=60e-9 MR=1
MNM2 Y A2 net15 VPW nm1p2_svt_lp W=230e-9 L=60e-9 MR=1
MNM1 Y A1 net15 VPW nm1p2_svt_lp W=230e-9 L=60e-9 MR=1
MNM0 Y A0 net15 VPW nm1p2_svt_lp W=230e-9 L=60e-9 MR=1
MPM3 Y B0 VDD VNW pm1p2_svt_lp W=300e-9 L=60e-9 MR=1
MPM2 net23 A2 VDD VNW pm1p2_svt_lp W=300e-9 L=60e-9 MR=1
MPM1 net24 A1 net23 VNW pm1p2_svt_lp W=300e-9 L=60e-9 MR=1
MPM0 Y A0 net24 VNW pm1p2_svt_lp W=300e-9 L=60e-9 MR=1
.ENDS
.SUBCKT OAI31X1_9TSVT A0 A1 A2 B0 VDD VSS Y VNW VPW
MNM3 net15 B0 VSS VPW nm1p2_svt_lp W=470e-9 L=60e-9 MR=1
MNM2 Y A2 net15 VPW nm1p2_svt_lp W=470e-9 L=60e-9 MR=1
MNM1 Y A1 net15 VPW nm1p2_svt_lp W=470e-9 L=60e-9 MR=1
MNM0 Y A0 net15 VPW nm1p2_svt_lp W=470e-9 L=60e-9 MR=1
MPM3 Y B0 VDD VNW pm1p2_svt_lp W=590e-9 L=60e-9 MR=1
MPM2 net23 A2 VDD VNW pm1p2_svt_lp W=590e-9 L=60e-9 MR=1
MPM1 net24 A1 net23 VNW pm1p2_svt_lp W=590e-9 L=60e-9 MR=1
MPM0 Y A0 net24 VNW pm1p2_svt_lp W=590e-9 L=60e-9 MR=1
.ENDS
.SUBCKT OAI31X2_9TSVT A0 A1 A2 B0 VDD VSS Y VNW VPW
MNM3 net15 B0 VSS VPW nm1p2_svt_lp W=940e-9 L=60e-9 MR=1
MNM2 Y A2 net15 VPW nm1p2_svt_lp W=940e-9 L=60e-9 MR=1
MNM1 Y A1 net15 VPW nm1p2_svt_lp W=940e-9 L=60e-9 MR=1
MNM0 Y A0 net15 VPW nm1p2_svt_lp W=940e-9 L=60e-9 MR=1
MPM3 Y B0 VDD VNW pm1p2_svt_lp W=1.18e-6 L=60e-9 MR=1
MPM2 net23 A2 VDD VNW pm1p2_svt_lp W=1.18e-6 L=60e-9 MR=1
MPM1 net24 A1 net23 VNW pm1p2_svt_lp W=1.18e-6 L=60e-9 MR=1
MPM0 Y A0 net24 VNW pm1p2_svt_lp W=1.18e-6 L=60e-9 MR=1
.ENDS
.SUBCKT OAI31X4_9TSVT A0 A1 A2 B0 VDD VSS Y VNW VPW
MNM3 net15 B0 VSS VPW nm1p2_svt_lp W=1.88e-6 L=60e-9 MR=1
MNM2 Y A2 net15 VPW nm1p2_svt_lp W=1.88e-6 L=60e-9 MR=1
MNM1 Y A1 net15 VPW nm1p2_svt_lp W=1.88e-6 L=60e-9 MR=1
MNM0 Y A0 net15 VPW nm1p2_svt_lp W=1.88e-6 L=60e-9 MR=1
MPM3 Y B0 VDD VNW pm1p2_svt_lp W=2.36e-6 L=60e-9 MR=1
MPM2 net23 A2 VDD VNW pm1p2_svt_lp W=2.36e-6 L=60e-9 MR=1
MPM1 net24 A1 net23 VNW pm1p2_svt_lp W=2.36e-6 L=60e-9 MR=1
MPM0 Y A0 net24 VNW pm1p2_svt_lp W=2.36e-6 L=60e-9 MR=1
.ENDS
.SUBCKT OAI32X0P5_9TSVT A0 A1 A2 B0 B1 VDD VSS Y VNW VPW
MNM4 net17 B1 VSS VPW nm1p2_svt_lp W=230e-9 L=60e-9 MR=1
MNM3 net17 B0 VSS VPW nm1p2_svt_lp W=230e-9 L=60e-9 MR=1
MNM2 Y A2 net17 VPW nm1p2_svt_lp W=230e-9 L=60e-9 MR=1
MNM1 Y A1 net17 VPW nm1p2_svt_lp W=230e-9 L=60e-9 MR=1
MNM0 Y A0 net17 VPW nm1p2_svt_lp W=230e-9 L=60e-9 MR=1
MPM4 net25 B1 VDD VNW pm1p2_svt_lp W=300e-9 L=60e-9 MR=1
MPM3 Y B0 net25 VNW pm1p2_svt_lp W=300e-9 L=60e-9 MR=1
MPM2 net26 A2 VDD VNW pm1p2_svt_lp W=300e-9 L=60e-9 MR=1
MPM1 net27 A1 net26 VNW pm1p2_svt_lp W=300e-9 L=60e-9 MR=1
MPM0 Y A0 net27 VNW pm1p2_svt_lp W=300e-9 L=60e-9 MR=1
.ENDS
.SUBCKT OAI32X1_9TSVT A0 A1 A2 B0 B1 VDD VSS Y VNW VPW
MNM4 net17 B1 VSS VPW nm1p2_svt_lp W=470e-9 L=60e-9 MR=1
MNM3 net17 B0 VSS VPW nm1p2_svt_lp W=470e-9 L=60e-9 MR=1
MNM2 Y A2 net17 VPW nm1p2_svt_lp W=470e-9 L=60e-9 MR=1
MNM1 Y A1 net17 VPW nm1p2_svt_lp W=470e-9 L=60e-9 MR=1
MNM0 Y A0 net17 VPW nm1p2_svt_lp W=470e-9 L=60e-9 MR=1
MPM4 net25 B1 VDD VNW pm1p2_svt_lp W=590e-9 L=60e-9 MR=1
MPM3 Y B0 net25 VNW pm1p2_svt_lp W=590e-9 L=60e-9 MR=1
MPM2 net26 A2 VDD VNW pm1p2_svt_lp W=590e-9 L=60e-9 MR=1
MPM1 net27 A1 net26 VNW pm1p2_svt_lp W=590e-9 L=60e-9 MR=1
MPM0 Y A0 net27 VNW pm1p2_svt_lp W=590e-9 L=60e-9 MR=1
.ENDS
.SUBCKT OAI32X2_9TSVT A0 A1 A2 B0 B1 VDD VSS Y VNW VPW
MNM4 net17 B1 VSS VPW nm1p2_svt_lp W=940e-9 L=60e-9 MR=1
MNM3 net17 B0 VSS VPW nm1p2_svt_lp W=940e-9 L=60e-9 MR=1
MNM2 Y A2 net17 VPW nm1p2_svt_lp W=940e-9 L=60e-9 MR=1
MNM1 Y A1 net17 VPW nm1p2_svt_lp W=940e-9 L=60e-9 MR=1
MNM0 Y A0 net17 VPW nm1p2_svt_lp W=940e-9 L=60e-9 MR=1
MPM4 net25 B1 VDD VNW pm1p2_svt_lp W=1.18e-6 L=60e-9 MR=1
MPM3 Y B0 net25 VNW pm1p2_svt_lp W=1.18e-6 L=60e-9 MR=1
MPM2 net26 A2 VDD VNW pm1p2_svt_lp W=1.18e-6 L=60e-9 MR=1
MPM1 net27 A1 net26 VNW pm1p2_svt_lp W=1.18e-6 L=60e-9 MR=1
MPM0 Y A0 net27 VNW pm1p2_svt_lp W=1.18e-6 L=60e-9 MR=1
.ENDS
.SUBCKT OAI32X4_9TSVT A0 A1 A2 B0 B1 VDD VSS Y VNW VPW
MNM4 net17 B1 VSS VPW nm1p2_svt_lp W=1.88e-6 L=60e-9 MR=1
MNM3 net17 B0 VSS VPW nm1p2_svt_lp W=1.88e-6 L=60e-9 MR=1
MNM2 Y A2 net17 VPW nm1p2_svt_lp W=1.88e-6 L=60e-9 MR=1
MNM1 Y A1 net17 VPW nm1p2_svt_lp W=1.88e-6 L=60e-9 MR=1
MNM0 Y A0 net17 VPW nm1p2_svt_lp W=1.88e-6 L=60e-9 MR=1
MPM4 net25 B1 VDD VNW pm1p2_svt_lp W=2.36e-6 L=60e-9 MR=1
MPM3 Y B0 net25 VNW pm1p2_svt_lp W=2.36e-6 L=60e-9 MR=1
MPM2 net26 A2 VDD VNW pm1p2_svt_lp W=2.36e-6 L=60e-9 MR=1
MPM1 net27 A1 net26 VNW pm1p2_svt_lp W=2.36e-6 L=60e-9 MR=1
MPM0 Y A0 net27 VNW pm1p2_svt_lp W=2.36e-6 L=60e-9 MR=1
.ENDS
.SUBCKT OAI33X0P5_9TSVT A0 A1 A2 B0 B1 B2 VDD VSS Y VNW VPW
MNM5 net19 B2 VSS VPW nm1p2_svt_lp W=230e-9 L=60e-9 MR=1
MNM4 net19 B1 VSS VPW nm1p2_svt_lp W=230e-9 L=60e-9 MR=1
MNM3 net19 B0 VSS VPW nm1p2_svt_lp W=230e-9 L=60e-9 MR=1
MNM2 Y A2 net19 VPW nm1p2_svt_lp W=230e-9 L=60e-9 MR=1
MNM1 Y A1 net19 VPW nm1p2_svt_lp W=230e-9 L=60e-9 MR=1
MNM0 Y A0 net19 VPW nm1p2_svt_lp W=230e-9 L=60e-9 MR=1
MPM5 net28 B2 VDD VNW pm1p2_svt_lp W=300e-9 L=60e-9 MR=1
MPM4 net29 B1 net28 VNW pm1p2_svt_lp W=300e-9 L=60e-9 MR=1
MPM3 Y B0 net29 VNW pm1p2_svt_lp W=300e-9 L=60e-9 MR=1
MPM2 net30 A2 VDD VNW pm1p2_svt_lp W=300e-9 L=60e-9 MR=1
MPM1 net31 A1 net30 VNW pm1p2_svt_lp W=300e-9 L=60e-9 MR=1
MPM0 Y A0 net31 VNW pm1p2_svt_lp W=300e-9 L=60e-9 MR=1
.ENDS
.SUBCKT OAI33X1_9TSVT A0 A1 A2 B0 B1 B2 VDD VSS Y VNW VPW
MNM5 net19 B2 VSS VPW nm1p2_svt_lp W=470e-9 L=60e-9 MR=1
MNM4 net19 B1 VSS VPW nm1p2_svt_lp W=470e-9 L=60e-9 MR=1
MNM3 net19 B0 VSS VPW nm1p2_svt_lp W=470e-9 L=60e-9 MR=1
MNM2 Y A2 net19 VPW nm1p2_svt_lp W=470e-9 L=60e-9 MR=1
MNM1 Y A1 net19 VPW nm1p2_svt_lp W=470e-9 L=60e-9 MR=1
MNM0 Y A0 net19 VPW nm1p2_svt_lp W=470e-9 L=60e-9 MR=1
MPM5 net28 B2 VDD VNW pm1p2_svt_lp W=590e-9 L=60e-9 MR=1
MPM4 net29 B1 net28 VNW pm1p2_svt_lp W=590e-9 L=60e-9 MR=1
MPM3 Y B0 net29 VNW pm1p2_svt_lp W=590e-9 L=60e-9 MR=1
MPM2 net30 A2 VDD VNW pm1p2_svt_lp W=590e-9 L=60e-9 MR=1
MPM1 net31 A1 net30 VNW pm1p2_svt_lp W=590e-9 L=60e-9 MR=1
MPM0 Y A0 net31 VNW pm1p2_svt_lp W=590e-9 L=60e-9 MR=1
.ENDS
.SUBCKT OAI33X2_9TSVT A0 A1 A2 B0 B1 B2 VDD VSS Y VNW VPW
MNM5 net19 B2 VSS VPW nm1p2_svt_lp W=940e-9 L=60e-9 MR=1
MNM4 net19 B1 VSS VPW nm1p2_svt_lp W=940e-9 L=60e-9 MR=1
MNM3 net19 B0 VSS VPW nm1p2_svt_lp W=940e-9 L=60e-9 MR=1
MNM2 Y A2 net19 VPW nm1p2_svt_lp W=940e-9 L=60e-9 MR=1
MNM1 Y A1 net19 VPW nm1p2_svt_lp W=940e-9 L=60e-9 MR=1
MNM0 Y A0 net19 VPW nm1p2_svt_lp W=940e-9 L=60e-9 MR=1
MPM5 net28 B2 VDD VNW pm1p2_svt_lp W=1.18e-6 L=60e-9 MR=1
MPM4 net29 B1 net28 VNW pm1p2_svt_lp W=1.18e-6 L=60e-9 MR=1
MPM3 Y B0 net29 VNW pm1p2_svt_lp W=1.18e-6 L=60e-9 MR=1
MPM2 net30 A2 VDD VNW pm1p2_svt_lp W=1.18e-6 L=60e-9 MR=1
MPM1 net31 A1 net30 VNW pm1p2_svt_lp W=1.18e-6 L=60e-9 MR=1
MPM0 Y A0 net31 VNW pm1p2_svt_lp W=1.18e-6 L=60e-9 MR=1
.ENDS
.SUBCKT OAI33X4_9TSVT A0 A1 A2 B0 B1 B2 VDD VSS Y VNW VPW
MNM5 net19 B2 VSS VPW nm1p2_svt_lp W=1.88e-6 L=60e-9 MR=1
MNM4 net19 B1 VSS VPW nm1p2_svt_lp W=1.88e-6 L=60e-9 MR=1
MNM3 net19 B0 VSS VPW nm1p2_svt_lp W=1.88e-6 L=60e-9 MR=1
MNM2 Y A2 net19 VPW nm1p2_svt_lp W=1.88e-6 L=60e-9 MR=1
MNM1 Y A1 net19 VPW nm1p2_svt_lp W=1.88e-6 L=60e-9 MR=1
MNM0 Y A0 net19 VPW nm1p2_svt_lp W=1.88e-6 L=60e-9 MR=1
MPM5 net28 B2 VDD VNW pm1p2_svt_lp W=2.36e-6 L=60e-9 MR=1
MPM4 net29 B1 net28 VNW pm1p2_svt_lp W=2.36e-6 L=60e-9 MR=1
MPM3 Y B0 net29 VNW pm1p2_svt_lp W=2.36e-6 L=60e-9 MR=1
MPM2 net30 A2 VDD VNW pm1p2_svt_lp W=2.36e-6 L=60e-9 MR=1
MPM1 net31 A1 net30 VNW pm1p2_svt_lp W=2.36e-6 L=60e-9 MR=1
MPM0 Y A0 net31 VNW pm1p2_svt_lp W=2.36e-6 L=60e-9 MR=1
.ENDS
.SUBCKT OR2X0P5_9TSVT A B VDD VSS Y VNW VPW
MPM2 Y net13 VDD VNW pm1p2_svt_lp W=300e-9 L=60e-9 MR=1
MPM1 net18 B VDD VNW pm1p2_svt_lp W=300e-9 L=60e-9 MR=1
MPM0 net13 A net18 VNW pm1p2_svt_lp W=300e-9 L=60e-9 MR=1
MNM2 Y net13 VSS VPW nm1p2_svt_lp W=230e-9 L=60e-9 MR=1
MNM1 net13 B VSS VPW nm1p2_svt_lp W=230e-9 L=60e-9 MR=1
MNM0 net13 A VSS VPW nm1p2_svt_lp W=230e-9 L=60e-9 MR=1
.ENDS
.SUBCKT OR2X1_9TSVT A B VDD VSS Y VNW VPW
MPM2 Y net13 VDD VNW pm1p2_svt_lp W=590e-9 L=60e-9 MR=1
MPM1 net18 B VDD VNW pm1p2_svt_lp W=300e-9 L=60e-9 MR=1
MPM0 net13 A net18 VNW pm1p2_svt_lp W=300e-9 L=60e-9 MR=1
MNM2 Y net13 VSS VPW nm1p2_svt_lp W=470e-9 L=60e-9 MR=1
MNM1 net13 B VSS VPW nm1p2_svt_lp W=230e-9 L=60e-9 MR=1
MNM0 net13 A VSS VPW nm1p2_svt_lp W=230e-9 L=60e-9 MR=1
.ENDS
.SUBCKT OR2X2_9TSVT A B VDD VSS Y VNW VPW
MPM2 Y net13 VDD VNW pm1p2_svt_lp W=1.18e-6 L=60e-9 MR=1
MPM1 net18 B VDD VNW pm1p2_svt_lp W=590e-9 L=60e-9 MR=1
MPM0 net13 A net18 VNW pm1p2_svt_lp W=590e-9 L=60e-9 MR=1
MNM2 Y net13 VSS VPW nm1p2_svt_lp W=940e-9 L=60e-9 MR=1
MNM1 net13 B VSS VPW nm1p2_svt_lp W=470e-9 L=60e-9 MR=1
MNM0 net13 A VSS VPW nm1p2_svt_lp W=470e-9 L=60e-9 MR=1
.ENDS
.SUBCKT OR2X3_9TSVT A B VDD VSS Y VNW VPW
MPM2 Y net13 VDD VNW pm1p2_svt_lp W=1.77e-6 L=60e-9 MR=1
MPM1 net18 B VDD VNW pm1p2_svt_lp W=590e-9 L=60e-9 MR=1
MPM0 net13 A net18 VNW pm1p2_svt_lp W=590e-9 L=60e-9 MR=1
MNM2 Y net13 VSS VPW nm1p2_svt_lp W=1.41e-6 L=60e-9 MR=1
MNM1 net13 B VSS VPW nm1p2_svt_lp W=470e-9 L=60e-9 MR=1
MNM0 net13 A VSS VPW nm1p2_svt_lp W=470e-9 L=60e-9 MR=1
.ENDS
.SUBCKT OR2X4_9TSVT A B VDD VSS Y VNW VPW
MPM2 Y net13 VDD VNW pm1p2_svt_lp W=2.36e-6 L=60e-9 MR=1
MPM1 net18 B VDD VNW pm1p2_svt_lp W=1.18e-6 L=60e-9 MR=1
MPM0 net13 A net18 VNW pm1p2_svt_lp W=1.18e-6 L=60e-9 MR=1
MNM2 Y net13 VSS VPW nm1p2_svt_lp W=1.88e-6 L=60e-9 MR=1
MNM1 net13 B VSS VPW nm1p2_svt_lp W=940e-9 L=60e-9 MR=1
MNM0 net13 A VSS VPW nm1p2_svt_lp W=940e-9 L=60e-9 MR=1
.ENDS
.SUBCKT OR2X6_9TSVT A B VDD VSS Y VNW VPW
MPM2 Y net13 VDD VNW pm1p2_svt_lp W=3.54e-6 L=60e-9 MR=1
MPM1 net18 B VDD VNW pm1p2_svt_lp W=1.18e-6 L=60e-9 MR=1
MPM0 net13 A net18 VNW pm1p2_svt_lp W=1.18e-6 L=60e-9 MR=1
MNM2 Y net13 VSS VPW nm1p2_svt_lp W=2.82e-6 L=60e-9 MR=1
MNM1 net13 B VSS VPW nm1p2_svt_lp W=940e-9 L=60e-9 MR=1
MNM0 net13 A VSS VPW nm1p2_svt_lp W=940e-9 L=60e-9 MR=1
.ENDS
.SUBCKT OR2X8_9TSVT A B VDD VSS Y VNW VPW
MPM2 Y net13 VDD VNW pm1p2_svt_lp W=4.72e-6 L=60e-9 MR=1
MPM1 net18 B VDD VNW pm1p2_svt_lp W=1.77e-6 L=60e-9 MR=1
MPM0 net13 A net18 VNW pm1p2_svt_lp W=1.77e-6 L=60e-9 MR=1
MNM2 Y net13 VSS VPW nm1p2_svt_lp W=3.76e-6 L=60e-9 MR=1
MNM1 net13 B VSS VPW nm1p2_svt_lp W=1.41e-6 L=60e-9 MR=1
MNM0 net13 A VSS VPW nm1p2_svt_lp W=1.41e-6 L=60e-9 MR=1
.ENDS
.SUBCKT OR3X0P5_9TSVT A B C VDD VSS Y VNW VPW
MPM3 Y net17 VDD VNW pm1p2_svt_lp W=300e-9 L=60e-9 MR=1
MPM2 net22 C VDD VNW pm1p2_svt_lp W=300e-9 L=60e-9 MR=1
MPM1 net23 B net22 VNW pm1p2_svt_lp W=300e-9 L=60e-9 MR=1
MPM0 net17 A net23 VNW pm1p2_svt_lp W=300e-9 L=60e-9 MR=1
MNM3 Y net17 VSS VPW nm1p2_svt_lp W=230e-9 L=60e-9 MR=1
MNM2 net17 C VSS VPW nm1p2_svt_lp W=230e-9 L=60e-9 MR=1
MNM1 net17 B VSS VPW nm1p2_svt_lp W=230e-9 L=60e-9 MR=1
MNM0 net17 A VSS VPW nm1p2_svt_lp W=230e-9 L=60e-9 MR=1
.ENDS
.SUBCKT OR3X1_9TSVT A B C VDD VSS Y VNW VPW
MPM3 Y net17 VDD VNW pm1p2_svt_lp W=590e-9 L=60e-9 MR=1
MPM2 net22 C VDD VNW pm1p2_svt_lp W=300e-9 L=60e-9 MR=1
MPM1 net23 B net22 VNW pm1p2_svt_lp W=300e-9 L=60e-9 MR=1
MPM0 net17 A net23 VNW pm1p2_svt_lp W=300e-9 L=60e-9 MR=1
MNM3 Y net17 VSS VPW nm1p2_svt_lp W=470e-9 L=60e-9 MR=1
MNM2 net17 C VSS VPW nm1p2_svt_lp W=230e-9 L=60e-9 MR=1
MNM1 net17 B VSS VPW nm1p2_svt_lp W=230e-9 L=60e-9 MR=1
MNM0 net17 A VSS VPW nm1p2_svt_lp W=230e-9 L=60e-9 MR=1
.ENDS
.SUBCKT OR3X2_9TSVT A B C VDD VSS Y VNW VPW
MPM3 Y net17 VDD VNW pm1p2_svt_lp W=1.18e-6 L=60e-9 MR=1
MPM2 net22 C VDD VNW pm1p2_svt_lp W=590e-9 L=60e-9 MR=1
MPM1 net23 B net22 VNW pm1p2_svt_lp W=590e-9 L=60e-9 MR=1
MPM0 net17 A net23 VNW pm1p2_svt_lp W=590e-9 L=60e-9 MR=1
MNM3 Y net17 VSS VPW nm1p2_svt_lp W=940e-9 L=60e-9 MR=1
MNM2 net17 C VSS VPW nm1p2_svt_lp W=470e-9 L=60e-9 MR=1
MNM1 net17 B VSS VPW nm1p2_svt_lp W=470e-9 L=60e-9 MR=1
MNM0 net17 A VSS VPW nm1p2_svt_lp W=470e-9 L=60e-9 MR=1
.ENDS
.SUBCKT OR3X3_9TSVT A B C VDD VSS Y VNW VPW
MPM3 Y net17 VDD VNW pm1p2_svt_lp W=1.77e-6 L=60e-9 MR=1
MPM2 net22 C VDD VNW pm1p2_svt_lp W=590e-9 L=60e-9 MR=1
MPM1 net23 B net22 VNW pm1p2_svt_lp W=590e-9 L=60e-9 MR=1
MPM0 net17 A net23 VNW pm1p2_svt_lp W=590e-9 L=60e-9 MR=1
MNM3 Y net17 VSS VPW nm1p2_svt_lp W=1.41e-6 L=60e-9 MR=1
MNM2 net17 C VSS VPW nm1p2_svt_lp W=470e-9 L=60e-9 MR=1
MNM1 net17 B VSS VPW nm1p2_svt_lp W=470e-9 L=60e-9 MR=1
MNM0 net17 A VSS VPW nm1p2_svt_lp W=470e-9 L=60e-9 MR=1
.ENDS
.SUBCKT OR3X4_9TSVT A B C VDD VSS Y VNW VPW
MPM3 Y net17 VDD VNW pm1p2_svt_lp W=2.36e-6 L=60e-9 MR=1
MPM2 net22 C VDD VNW pm1p2_svt_lp W=1.18e-6 L=60e-9 MR=1
MPM1 net23 B net22 VNW pm1p2_svt_lp W=1.18e-6 L=60e-9 MR=1
MPM0 net17 A net23 VNW pm1p2_svt_lp W=1.18e-6 L=60e-9 MR=1
MNM3 Y net17 VSS VPW nm1p2_svt_lp W=1.88e-6 L=60e-9 MR=1
MNM2 net17 C VSS VPW nm1p2_svt_lp W=940e-9 L=60e-9 MR=1
MNM1 net17 B VSS VPW nm1p2_svt_lp W=940e-9 L=60e-9 MR=1
MNM0 net17 A VSS VPW nm1p2_svt_lp W=940e-9 L=60e-9 MR=1
.ENDS
.SUBCKT OR3X6_9TSVT A B C VDD VSS Y VNW VPW
MPM3 Y net17 VDD VNW pm1p2_svt_lp W=3.54e-6 L=60e-9 MR=1
MPM2 net22 C VDD VNW pm1p2_svt_lp W=1.18e-6 L=60e-9 MR=1
MPM1 net23 B net22 VNW pm1p2_svt_lp W=1.18e-6 L=60e-9 MR=1
MPM0 net17 A net23 VNW pm1p2_svt_lp W=1.18e-6 L=60e-9 MR=1
MNM3 Y net17 VSS VPW nm1p2_svt_lp W=2.82e-6 L=60e-9 MR=1
MNM2 net17 C VSS VPW nm1p2_svt_lp W=940e-9 L=60e-9 MR=1
MNM1 net17 B VSS VPW nm1p2_svt_lp W=940e-9 L=60e-9 MR=1
MNM0 net17 A VSS VPW nm1p2_svt_lp W=940e-9 L=60e-9 MR=1
.ENDS
.SUBCKT OR3X8_9TSVT A B C VDD VSS Y VNW VPW
MPM3 Y net17 VDD VNW pm1p2_svt_lp W=4.72e-6 L=60e-9 MR=1
MPM2 net22 C VDD VNW pm1p2_svt_lp W=1.77e-6 L=60e-9 MR=1
MPM1 net23 B net22 VNW pm1p2_svt_lp W=1.77e-6 L=60e-9 MR=1
MPM0 net17 A net23 VNW pm1p2_svt_lp W=1.77e-6 L=60e-9 MR=1
MNM3 Y net17 VSS VPW nm1p2_svt_lp W=3.76e-6 L=60e-9 MR=1
MNM2 net17 C VSS VPW nm1p2_svt_lp W=1.41e-6 L=60e-9 MR=1
MNM1 net17 B VSS VPW nm1p2_svt_lp W=1.41e-6 L=60e-9 MR=1
MNM0 net17 A VSS VPW nm1p2_svt_lp W=1.41e-6 L=60e-9 MR=1
.ENDS
.SUBCKT OR4X0P5_9TSVT A B C D VDD VSS Y VNW VPW
MPM4 Y net19 VDD VNW pm1p2_svt_lp W=300e-9 L=60e-9 MR=1
MPM3 net25 D VDD VNW pm1p2_svt_lp W=300e-9 L=60e-9 MR=1
MPM2 net26 C net25 VNW pm1p2_svt_lp W=300e-9 L=60e-9 MR=1
MPM1 net27 B net26 VNW pm1p2_svt_lp W=300e-9 L=60e-9 MR=1
MPM0 net19 A net27 VNW pm1p2_svt_lp W=300e-9 L=60e-9 MR=1
MNM4 Y net19 VSS VPW nm1p2_svt_lp W=230e-9 L=60e-9 MR=1
MNM3 net19 D VSS VPW nm1p2_svt_lp W=230e-9 L=60e-9 MR=1
MNM2 net19 C VSS VPW nm1p2_svt_lp W=230e-9 L=60e-9 MR=1
MNM1 net19 B VSS VPW nm1p2_svt_lp W=230e-9 L=60e-9 MR=1
MNM0 net19 A VSS VPW nm1p2_svt_lp W=230e-9 L=60e-9 MR=1
.ENDS
.SUBCKT OR4X1_9TSVT A B C D VDD VSS Y VNW VPW
MPM4 Y net19 VDD VNW pm1p2_svt_lp W=590e-9 L=60e-9 MR=1
MPM3 net25 D VDD VNW pm1p2_svt_lp W=300e-9 L=60e-9 MR=1
MPM2 net26 C net25 VNW pm1p2_svt_lp W=300e-9 L=60e-9 MR=1
MPM1 net27 B net26 VNW pm1p2_svt_lp W=300e-9 L=60e-9 MR=1
MPM0 net19 A net27 VNW pm1p2_svt_lp W=300e-9 L=60e-9 MR=1
MNM4 Y net19 VSS VPW nm1p2_svt_lp W=470e-9 L=60e-9 MR=1
MNM3 net19 D VSS VPW nm1p2_svt_lp W=230e-9 L=60e-9 MR=1
MNM2 net19 C VSS VPW nm1p2_svt_lp W=230e-9 L=60e-9 MR=1
MNM1 net19 B VSS VPW nm1p2_svt_lp W=230e-9 L=60e-9 MR=1
MNM0 net19 A VSS VPW nm1p2_svt_lp W=230e-9 L=60e-9 MR=1
.ENDS
.SUBCKT OR4X2_9TSVT A B C D VDD VSS Y VNW VPW
MPM4 Y net19 VDD VNW pm1p2_svt_lp W=1.18e-6 L=60e-9 MR=1
MPM3 net25 D VDD VNW pm1p2_svt_lp W=590e-9 L=60e-9 MR=1
MPM2 net26 C net25 VNW pm1p2_svt_lp W=590e-9 L=60e-9 MR=1
MPM1 net27 B net26 VNW pm1p2_svt_lp W=590e-9 L=60e-9 MR=1
MPM0 net19 A net27 VNW pm1p2_svt_lp W=590e-9 L=60e-9 MR=1
MNM4 Y net19 VSS VPW nm1p2_svt_lp W=940e-9 L=60e-9 MR=1
MNM3 net19 D VSS VPW nm1p2_svt_lp W=470e-9 L=60e-9 MR=1
MNM2 net19 C VSS VPW nm1p2_svt_lp W=470e-9 L=60e-9 MR=1
MNM1 net19 B VSS VPW nm1p2_svt_lp W=470e-9 L=60e-9 MR=1
MNM0 net19 A VSS VPW nm1p2_svt_lp W=470e-9 L=60e-9 MR=1
.ENDS
.SUBCKT OR4X3_9TSVT A B C D VDD VSS Y VNW VPW
MPM4 Y net19 VDD VNW pm1p2_svt_lp W=1.77e-6 L=60e-9 MR=1
MPM3 net25 D VDD VNW pm1p2_svt_lp W=590e-9 L=60e-9 MR=1
MPM2 net26 C net25 VNW pm1p2_svt_lp W=590e-9 L=60e-9 MR=1
MPM1 net27 B net26 VNW pm1p2_svt_lp W=590e-9 L=60e-9 MR=1
MPM0 net19 A net27 VNW pm1p2_svt_lp W=590e-9 L=60e-9 MR=1
MNM4 Y net19 VSS VPW nm1p2_svt_lp W=1.41e-6 L=60e-9 MR=1
MNM3 net19 D VSS VPW nm1p2_svt_lp W=470e-9 L=60e-9 MR=1
MNM2 net19 C VSS VPW nm1p2_svt_lp W=470e-9 L=60e-9 MR=1
MNM1 net19 B VSS VPW nm1p2_svt_lp W=470e-9 L=60e-9 MR=1
MNM0 net19 A VSS VPW nm1p2_svt_lp W=470e-9 L=60e-9 MR=1
.ENDS
.SUBCKT OR4X4_9TSVT A B C D VDD VSS Y VNW VPW
MPM4 Y net19 VDD VNW pm1p2_svt_lp W=2.36e-6 L=60e-9 MR=1
MPM3 net25 D VDD VNW pm1p2_svt_lp W=1.18e-6 L=60e-9 MR=1
MPM2 net26 C net25 VNW pm1p2_svt_lp W=1.18e-6 L=60e-9 MR=1
MPM1 net27 B net26 VNW pm1p2_svt_lp W=1.18e-6 L=60e-9 MR=1
MPM0 net19 A net27 VNW pm1p2_svt_lp W=1.18e-6 L=60e-9 MR=1
MNM4 Y net19 VSS VPW nm1p2_svt_lp W=1.88e-6 L=60e-9 MR=1
MNM3 net19 D VSS VPW nm1p2_svt_lp W=940e-9 L=60e-9 MR=1
MNM2 net19 C VSS VPW nm1p2_svt_lp W=940e-9 L=60e-9 MR=1
MNM1 net19 B VSS VPW nm1p2_svt_lp W=940e-9 L=60e-9 MR=1
MNM0 net19 A VSS VPW nm1p2_svt_lp W=940e-9 L=60e-9 MR=1
.ENDS
.SUBCKT OR4X6_9TSVT A B C D VDD VSS Y VNW VPW
MPM4 Y net19 VDD VNW pm1p2_svt_lp W=3.54e-6 L=60e-9 MR=1
MPM3 net25 D VDD VNW pm1p2_svt_lp W=1.18e-6 L=60e-9 MR=1
MPM2 net26 C net25 VNW pm1p2_svt_lp W=1.18e-6 L=60e-9 MR=1
MPM1 net27 B net26 VNW pm1p2_svt_lp W=1.18e-6 L=60e-9 MR=1
MPM0 net19 A net27 VNW pm1p2_svt_lp W=1.18e-6 L=60e-9 MR=1
MNM4 Y net19 VSS VPW nm1p2_svt_lp W=2.82e-6 L=60e-9 MR=1
MNM3 net19 D VSS VPW nm1p2_svt_lp W=940e-9 L=60e-9 MR=1
MNM2 net19 C VSS VPW nm1p2_svt_lp W=940e-9 L=60e-9 MR=1
MNM1 net19 B VSS VPW nm1p2_svt_lp W=940e-9 L=60e-9 MR=1
MNM0 net19 A VSS VPW nm1p2_svt_lp W=940e-9 L=60e-9 MR=1
.ENDS
.SUBCKT OR4X8_9TSVT A B C D VDD VSS Y VNW VPW
MPM4 Y net19 VDD VNW pm1p2_svt_lp W=4.72e-6 L=60e-9 MR=1
MPM3 net25 D VDD VNW pm1p2_svt_lp W=1.77e-6 L=60e-9 MR=1
MPM2 net26 C net25 VNW pm1p2_svt_lp W=1.77e-6 L=60e-9 MR=1
MPM1 net27 B net26 VNW pm1p2_svt_lp W=1.77e-6 L=60e-9 MR=1
MPM0 net19 A net27 VNW pm1p2_svt_lp W=1.77e-6 L=60e-9 MR=1
MNM4 Y net19 VSS VPW nm1p2_svt_lp W=3.76e-6 L=60e-9 MR=1
MNM3 net19 D VSS VPW nm1p2_svt_lp W=1.41e-6 L=60e-9 MR=1
MNM2 net19 C VSS VPW nm1p2_svt_lp W=1.41e-6 L=60e-9 MR=1
MNM1 net19 B VSS VPW nm1p2_svt_lp W=1.41e-6 L=60e-9 MR=1
MNM0 net19 A VSS VPW nm1p2_svt_lp W=1.41e-6 L=60e-9 MR=1
.ENDS
.SUBCKT SDFFKRNQX0P5_9TSVT CK D Q RN SE SI VDD VSS VNW VPW
MNM15 Q net45 VSS VPW nm1p2_svt_lp W=230e-9 L=60e-9 MR=1
MNM10 net51 net45 VSS VPW nm1p2_svt_lp W=150e-9 L=60e-9 MR=1
MNM11 net39 ckn net51 VPW nm1p2_svt_lp W=150e-9 L=60e-9 MR=1
MNM9 net45 net39 VSS VPW nm1p2_svt_lp W=230e-9 L=60e-9 MR=1
MNM8 net39 ckb net36 VPW nm1p2_svt_lp W=230e-9 L=60e-9 MR=1
MNM6 net53 net36 VSS VPW nm1p2_svt_lp W=150e-9 L=60e-9 MR=1
MNM7 net27 ckb net53 VPW nm1p2_svt_lp W=150e-9 L=60e-9 MR=1
MNM5 net36 net27 VSS VPW nm1p2_svt_lp W=230e-9 L=60e-9 MR=1
MNM3 net27 ckn net21 VPW nm1p2_svt_lp W=230e-9 L=60e-9 MR=1
MNM_SE0 sen SE VSS VPW nm1p2_svt_lp W=230e-9 L=60e-9 MR=1
MNMR2 net55 SI VSS VPW nm1p2_svt_lp W=230e-9 L=60e-9 MR=1
MNML2 net57 D VSS VPW nm1p2_svt_lp W=230e-9 L=60e-9 MR=1
MNM_RN net18 RN net57 VPW nm1p2_svt_lp W=230e-9 L=60e-9 MR=1
MNM_SE2 net21 SE net55 VPW nm1p2_svt_lp W=230e-9 L=60e-9 MR=1
MNM_SE1 net21 sen net18 VPW nm1p2_svt_lp W=230e-9 L=60e-9 MR=1
MNM1 ckb ckn VSS VPW nm1p2_svt_lp W=230e-9 L=60e-9 MR=1
MNM0 ckn CK VSS VPW nm1p2_svt_lp W=230e-9 L=60e-9 MR=1
MPM15 Q net45 VDD VNW pm1p2_svt_lp W=300e-9 L=60e-9 MR=1
MPM11 net39 ckb net52 VNW pm1p2_svt_lp W=150e-9 L=60e-9 MR=1
MPM10 net52 net45 VDD VNW pm1p2_svt_lp W=150e-9 L=60e-9 MR=1
MPM9 net45 net39 VDD VNW pm1p2_svt_lp W=300e-9 L=60e-9 MR=1
MPM8 net39 ckn net36 VNW pm1p2_svt_lp W=300e-9 L=60e-9 MR=1
MPM7 net27 ckn net54 VNW pm1p2_svt_lp W=150e-9 L=60e-9 MR=1
MPM6 net54 net36 VDD VNW pm1p2_svt_lp W=150e-9 L=60e-9 MR=1
MPM5 net36 net27 VDD VNW pm1p2_svt_lp W=300e-9 L=60e-9 MR=1
MPM3 net27 ckb net21 VNW pm1p2_svt_lp W=300e-9 L=60e-9 MR=1
MPM_SE0 sen SE VDD VNW pm1p2_svt_lp W=300e-9 L=60e-9 MR=1
MPMR2 net56 SI VDD VNW pm1p2_svt_lp W=300e-9 L=60e-9 MR=1
MPM_RN net18 RN VDD VNW pm1p2_svt_lp W=300e-9 L=60e-9 MR=1
MPML2 net18 D VDD VNW pm1p2_svt_lp W=300e-9 L=60e-9 MR=1
MPM_SE2 net21 sen net56 VNW pm1p2_svt_lp W=300e-9 L=60e-9 MR=1
MPM_SE1 net21 SE net18 VNW pm1p2_svt_lp W=300e-9 L=60e-9 MR=1
MPM1 ckb ckn VDD VNW pm1p2_svt_lp W=300e-9 L=60e-9 MR=1
MPM0 ckn CK VDD VNW pm1p2_svt_lp W=300e-9 L=60e-9 MR=1
.ENDS
.SUBCKT SDFFKRNQX1_9TSVT CK D Q RN SE SI VDD VSS VNW VPW
MNM15 Q net45 VSS VPW nm1p2_svt_lp W=470e-9 L=60e-9 MR=1
MNM10 net51 net45 VSS VPW nm1p2_svt_lp W=150e-9 L=60e-9 MR=1
MNM11 net39 ckn net51 VPW nm1p2_svt_lp W=150e-9 L=60e-9 MR=1
MNM9 net45 net39 VSS VPW nm1p2_svt_lp W=470e-9 L=60e-9 MR=1
MNM8 net39 ckb net36 VPW nm1p2_svt_lp W=470e-9 L=60e-9 MR=1
MNM6 net53 net36 VSS VPW nm1p2_svt_lp W=150e-9 L=60e-9 MR=1
MNM7 net27 ckb net53 VPW nm1p2_svt_lp W=150e-9 L=60e-9 MR=1
MNM5 net36 net27 VSS VPW nm1p2_svt_lp W=470e-9 L=60e-9 MR=1
MNM3 net27 ckn net21 VPW nm1p2_svt_lp W=470e-9 L=60e-9 MR=1
MNM_SE0 sen SE VSS VPW nm1p2_svt_lp W=230e-9 L=60e-9 MR=1
MNMR2 net55 SI VSS VPW nm1p2_svt_lp W=470e-9 L=60e-9 MR=1
MNML2 net57 D VSS VPW nm1p2_svt_lp W=470e-9 L=60e-9 MR=1
MNM_RN net18 RN net57 VPW nm1p2_svt_lp W=470e-9 L=60e-9 MR=1
MNM_SE2 net21 SE net55 VPW nm1p2_svt_lp W=470e-9 L=60e-9 MR=1
MNM_SE1 net21 sen net18 VPW nm1p2_svt_lp W=470e-9 L=60e-9 MR=1
MNM1 ckb ckn VSS VPW nm1p2_svt_lp W=230e-9 L=60e-9 MR=1
MNM0 ckn CK VSS VPW nm1p2_svt_lp W=230e-9 L=60e-9 MR=1
MPM15 Q net45 VDD VNW pm1p2_svt_lp W=590e-9 L=60e-9 MR=1
MPM11 net39 ckb net52 VNW pm1p2_svt_lp W=150e-9 L=60e-9 MR=1
MPM10 net52 net45 VDD VNW pm1p2_svt_lp W=150e-9 L=60e-9 MR=1
MPM9 net45 net39 VDD VNW pm1p2_svt_lp W=590e-9 L=60e-9 MR=1
MPM8 net39 ckn net36 VNW pm1p2_svt_lp W=590e-9 L=60e-9 MR=1
MPM7 net27 ckn net54 VNW pm1p2_svt_lp W=150e-9 L=60e-9 MR=1
MPM6 net54 net36 VDD VNW pm1p2_svt_lp W=150e-9 L=60e-9 MR=1
MPM5 net36 net27 VDD VNW pm1p2_svt_lp W=410e-9 L=60e-9 MR=1
MPM3 net27 ckb net21 VNW pm1p2_svt_lp W=410e-9 L=60e-9 MR=1
MPM_SE0 sen SE VDD VNW pm1p2_svt_lp W=300e-9 L=60e-9 MR=1
MPMR2 net56 SI VDD VNW pm1p2_svt_lp W=590e-9 L=60e-9 MR=1
MPM_RN net18 RN VDD VNW pm1p2_svt_lp W=590e-9 L=60e-9 MR=1
MPML2 net18 D VDD VNW pm1p2_svt_lp W=590e-9 L=60e-9 MR=1
MPM_SE2 net21 sen net56 VNW pm1p2_svt_lp W=590e-9 L=60e-9 MR=1
MPM_SE1 net21 SE net18 VNW pm1p2_svt_lp W=590e-9 L=60e-9 MR=1
MPM1 ckb ckn VDD VNW pm1p2_svt_lp W=300e-9 L=60e-9 MR=1
MPM0 ckn CK VDD VNW pm1p2_svt_lp W=300e-9 L=60e-9 MR=1
.ENDS
.SUBCKT SDFFKRNQX2_9TSVT CK D Q RN SE SI VDD VSS VNW VPW
MNM15 Q net45 VSS VPW nm1p2_svt_lp W=940e-9 L=60e-9 MR=1
MNM10 net51 net45 VSS VPW nm1p2_svt_lp W=150e-9 L=60e-9 MR=1
MNM11 net39 ckn net51 VPW nm1p2_svt_lp W=150e-9 L=60e-9 MR=1
MNM9 net45 net39 VSS VPW nm1p2_svt_lp W=470e-9 L=60e-9 MR=1
MNM8 net39 ckb net36 VPW nm1p2_svt_lp W=470e-9 L=60e-9 MR=1
MNM6 net53 net36 VSS VPW nm1p2_svt_lp W=150e-9 L=60e-9 MR=1
MNM7 net27 ckb net53 VPW nm1p2_svt_lp W=150e-9 L=60e-9 MR=1
MNM5 net36 net27 VSS VPW nm1p2_svt_lp W=470e-9 L=60e-9 MR=1
MNM3 net27 ckn net21 VPW nm1p2_svt_lp W=470e-9 L=60e-9 MR=1
MNM_SE0 sen SE VSS VPW nm1p2_svt_lp W=230e-9 L=60e-9 MR=1
MNMR2 net55 SI VSS VPW nm1p2_svt_lp W=470e-9 L=60e-9 MR=1
MNML2 net57 D VSS VPW nm1p2_svt_lp W=470e-9 L=60e-9 MR=1
MNM_RN net18 RN net57 VPW nm1p2_svt_lp W=470e-9 L=60e-9 MR=1
MNM_SE2 net21 SE net55 VPW nm1p2_svt_lp W=470e-9 L=60e-9 MR=1
MNM_SE1 net21 sen net18 VPW nm1p2_svt_lp W=470e-9 L=60e-9 MR=1
MNM1 ckb ckn VSS VPW nm1p2_svt_lp W=230e-9 L=60e-9 MR=1
MNM0 ckn CK VSS VPW nm1p2_svt_lp W=230e-9 L=60e-9 MR=1
MPM15 Q net45 VDD VNW pm1p2_svt_lp W=1.18e-6 L=60e-9 MR=1
MPM11 net39 ckb net52 VNW pm1p2_svt_lp W=150e-9 L=60e-9 MR=1
MPM10 net52 net45 VDD VNW pm1p2_svt_lp W=150e-9 L=60e-9 MR=1
MPM9 net45 net39 VDD VNW pm1p2_svt_lp W=590e-9 L=60e-9 MR=1
MPM8 net39 ckn net36 VNW pm1p2_svt_lp W=590e-9 L=60e-9 MR=1
MPM7 net27 ckn net54 VNW pm1p2_svt_lp W=150e-9 L=60e-9 MR=1
MPM6 net54 net36 VDD VNW pm1p2_svt_lp W=150e-9 L=60e-9 MR=1
MPM5 net36 net27 VDD VNW pm1p2_svt_lp W=410e-9 L=60e-9 MR=1
MPM3 net27 ckb net21 VNW pm1p2_svt_lp W=410e-9 L=60e-9 MR=1
MPM_SE0 sen SE VDD VNW pm1p2_svt_lp W=300e-9 L=60e-9 MR=1
MPMR2 net56 SI VDD VNW pm1p2_svt_lp W=590e-9 L=60e-9 MR=1
MPM_RN net18 RN VDD VNW pm1p2_svt_lp W=590e-9 L=60e-9 MR=1
MPML2 net18 D VDD VNW pm1p2_svt_lp W=590e-9 L=60e-9 MR=1
MPM_SE2 net21 sen net56 VNW pm1p2_svt_lp W=590e-9 L=60e-9 MR=1
MPM_SE1 net21 SE net18 VNW pm1p2_svt_lp W=590e-9 L=60e-9 MR=1
MPM1 ckb ckn VDD VNW pm1p2_svt_lp W=300e-9 L=60e-9 MR=1
MPM0 ckn CK VDD VNW pm1p2_svt_lp W=300e-9 L=60e-9 MR=1
.ENDS
.SUBCKT SDFFKRNQX4_9TSVT CK D Q RN SE SI VDD VSS VNW VPW
MNM15 Q net45 VSS VPW nm1p2_svt_lp W=1.88e-6 L=60e-9 MR=1
MNM10 net51 net45 VSS VPW nm1p2_svt_lp W=150e-9 L=60e-9 MR=1
MNM11 net39 ckn net51 VPW nm1p2_svt_lp W=150e-9 L=60e-9 MR=1
MNM9 net45 net39 VSS VPW nm1p2_svt_lp W=940e-9 L=60e-9 MR=1
MNM8 net39 ckb net36 VPW nm1p2_svt_lp W=940e-9 L=60e-9 MR=1
MNM6 net53 net36 VSS VPW nm1p2_svt_lp W=150e-9 L=60e-9 MR=1
MNM7 net27 ckb net53 VPW nm1p2_svt_lp W=150e-9 L=60e-9 MR=1
MNM5 net36 net27 VSS VPW nm1p2_svt_lp W=470e-9 L=60e-9 MR=1
MNM3 net27 ckn net21 VPW nm1p2_svt_lp W=470e-9 L=60e-9 MR=1
MNM_SE0 sen SE VSS VPW nm1p2_svt_lp W=230e-9 L=60e-9 MR=1
MNMR2 net55 SI VSS VPW nm1p2_svt_lp W=470e-9 L=60e-9 MR=1
MNML2 net57 D VSS VPW nm1p2_svt_lp W=470e-9 L=60e-9 MR=1
MNM_RN net18 RN net57 VPW nm1p2_svt_lp W=470e-9 L=60e-9 MR=1
MNM_SE2 net21 SE net55 VPW nm1p2_svt_lp W=470e-9 L=60e-9 MR=1
MNM_SE1 net21 sen net18 VPW nm1p2_svt_lp W=470e-9 L=60e-9 MR=1
MNM1 ckb ckn VSS VPW nm1p2_svt_lp W=470e-9 L=60e-9 MR=1
MNM0 ckn CK VSS VPW nm1p2_svt_lp W=470e-9 L=60e-9 MR=1
MPM15 Q net45 VDD VNW pm1p2_svt_lp W=2.36e-6 L=60e-9 MR=1
MPM11 net39 ckb net52 VNW pm1p2_svt_lp W=150e-9 L=60e-9 MR=1
MPM10 net52 net45 VDD VNW pm1p2_svt_lp W=150e-9 L=60e-9 MR=1
MPM9 net45 net39 VDD VNW pm1p2_svt_lp W=1.18e-6 L=60e-9 MR=1
MPM8 net39 ckn net36 VNW pm1p2_svt_lp W=1.18e-6 L=60e-9 MR=1
MPM7 net27 ckn net54 VNW pm1p2_svt_lp W=150e-9 L=60e-9 MR=1
MPM6 net54 net36 VDD VNW pm1p2_svt_lp W=150e-9 L=60e-9 MR=1
MPM5 net36 net27 VDD VNW pm1p2_svt_lp W=410e-9 L=60e-9 MR=1
MPM3 net27 ckb net21 VNW pm1p2_svt_lp W=410e-9 L=60e-9 MR=1
MPM_SE0 sen SE VDD VNW pm1p2_svt_lp W=300e-9 L=60e-9 MR=1
MPMR2 net56 SI VDD VNW pm1p2_svt_lp W=590e-9 L=60e-9 MR=1
MPM_RN net18 RN VDD VNW pm1p2_svt_lp W=590e-9 L=60e-9 MR=1
MPML2 net18 D VDD VNW pm1p2_svt_lp W=590e-9 L=60e-9 MR=1
MPM_SE2 net21 sen net56 VNW pm1p2_svt_lp W=590e-9 L=60e-9 MR=1
MPM_SE1 net21 SE net18 VNW pm1p2_svt_lp W=590e-9 L=60e-9 MR=1
MPM1 ckb ckn VDD VNW pm1p2_svt_lp W=590e-9 L=60e-9 MR=1
MPM0 ckn CK VDD VNW pm1p2_svt_lp W=390e-9 L=60e-9 MR=1
.ENDS
.SUBCKT SDFFKRSNQX0P5_9TSVT CK D Q RN SE SI SN VDD VSS VNW VPW
MNM15 Q net52 VSS VPW nm1p2_svt_lp W=230e-9 L=60e-9 MR=1
MNM11 net59 net52 VSS VPW nm1p2_svt_lp W=150e-9 L=60e-9 MR=1
MNM12 net46 ckn net59 VPW nm1p2_svt_lp W=150e-9 L=60e-9 MR=1
MNM10 net52 net46 VSS VPW nm1p2_svt_lp W=230e-9 L=60e-9 MR=1
MNM9 net46 ckb net43 VPW nm1p2_svt_lp W=230e-9 L=60e-9 MR=1
MNM7 net61 net43 VSS VPW nm1p2_svt_lp W=150e-9 L=60e-9 MR=1
MNM8 net34 ckb net61 VPW nm1p2_svt_lp W=150e-9 L=60e-9 MR=1
MNM6 net43 net34 VSS VPW nm1p2_svt_lp W=230e-9 L=60e-9 MR=1
MNM4 net34 ckn net26 VPW nm1p2_svt_lp W=230e-9 L=60e-9 MR=1
MNM_SE0 sen SE VSS VPW nm1p2_svt_lp W=230e-9 L=60e-9 MR=1
MNMR3 net63 SI VSS VPW nm1p2_svt_lp W=230e-9 L=60e-9 MR=1
MNM_SNN net22 SNN net17 VPW nm1p2_svt_lp W=230e-9 L=60e-9 MR=1
MNM_RN net17 RN VSS VPW nm1p2_svt_lp W=230e-9 L=60e-9 MR=1
MNML3 net22 D net17 VPW nm1p2_svt_lp W=230e-9 L=60e-9 MR=1
MNM_SE2 net26 SE net63 VPW nm1p2_svt_lp W=230e-9 L=60e-9 MR=1
MNM_SE1 net26 sen net22 VPW nm1p2_svt_lp W=230e-9 L=60e-9 MR=1
MNM2 SNN SN VSS VPW nm1p2_svt_lp W=230e-9 L=60e-9 MR=1
MNM1 ckb ckn VSS VPW nm1p2_svt_lp W=230e-9 L=60e-9 MR=1
MNM0 ckn CK VSS VPW nm1p2_svt_lp W=230e-9 L=60e-9 MR=1
MPM15 Q net52 VDD VNW pm1p2_svt_lp W=300e-9 L=60e-9 MR=1
MPM12 net46 ckb net60 VNW pm1p2_svt_lp W=150e-9 L=60e-9 MR=1
MPM11 net60 net52 VDD VNW pm1p2_svt_lp W=150e-9 L=60e-9 MR=1
MPM10 net52 net46 VDD VNW pm1p2_svt_lp W=300e-9 L=60e-9 MR=1
MPM9 net46 ckn net43 VNW pm1p2_svt_lp W=300e-9 L=60e-9 MR=1
MPM8 net34 ckn net62 VNW pm1p2_svt_lp W=150e-9 L=60e-9 MR=1
MPM7 net62 net43 VDD VNW pm1p2_svt_lp W=150e-9 L=60e-9 MR=1
MPM6 net43 net34 VDD VNW pm1p2_svt_lp W=300e-9 L=60e-9 MR=1
MPM4 net34 ckb net26 VNW pm1p2_svt_lp W=300e-9 L=60e-9 MR=1
MPM_SE0 sen SE VDD VNW pm1p2_svt_lp W=300e-9 L=60e-9 MR=1
MPMR3 net64 SI VDD VNW pm1p2_svt_lp W=300e-9 L=60e-9 MR=1
MPM_RN net22 RN VDD VNW pm1p2_svt_lp W=300e-9 L=60e-9 MR=1
MPM_SNN net65 SNN VDD VNW pm1p2_svt_lp W=300e-9 L=60e-9 MR=1
MPML3 net22 D net65 VNW pm1p2_svt_lp W=300e-9 L=60e-9 MR=1
MPM_SE2 net26 sen net64 VNW pm1p2_svt_lp W=300e-9 L=60e-9 MR=1
MPM_SE1 net26 SE net22 VNW pm1p2_svt_lp W=300e-9 L=60e-9 MR=1
MPM2 SNN SN VDD VNW pm1p2_svt_lp W=300e-9 L=60e-9 MR=1
MPM1 ckb ckn VDD VNW pm1p2_svt_lp W=300e-9 L=60e-9 MR=1
MPM0 ckn CK VDD VNW pm1p2_svt_lp W=300e-9 L=60e-9 MR=1
.ENDS
.SUBCKT SDFFKRSNQX1_9TSVT CK D Q RN SE SI SN VDD VSS VNW VPW
MNM15 Q net52 VSS VPW nm1p2_svt_lp W=470e-9 L=60e-9 MR=1
MNM11 net59 net52 VSS VPW nm1p2_svt_lp W=150e-9 L=60e-9 MR=1
MNM12 net46 ckn net59 VPW nm1p2_svt_lp W=150e-9 L=60e-9 MR=1
MNM10 net52 net46 VSS VPW nm1p2_svt_lp W=470e-9 L=60e-9 MR=1
MNM9 net46 ckb net43 VPW nm1p2_svt_lp W=470e-9 L=60e-9 MR=1
MNM7 net61 net43 VSS VPW nm1p2_svt_lp W=150e-9 L=60e-9 MR=1
MNM8 net34 ckb net61 VPW nm1p2_svt_lp W=150e-9 L=60e-9 MR=1
MNM6 net43 net34 VSS VPW nm1p2_svt_lp W=470e-9 L=60e-9 MR=1
MNM4 net34 ckn net26 VPW nm1p2_svt_lp W=470e-9 L=60e-9 MR=1
MNM_SE0 sen SE VSS VPW nm1p2_svt_lp W=230e-9 L=60e-9 MR=1
MNMR3 net63 SI VSS VPW nm1p2_svt_lp W=470e-9 L=60e-9 MR=1
MNM_SNN net22 SNN net17 VPW nm1p2_svt_lp W=470e-9 L=60e-9 MR=1
MNM_RN net17 RN VSS VPW nm1p2_svt_lp W=470e-9 L=60e-9 MR=1
MNML3 net22 D net17 VPW nm1p2_svt_lp W=470e-9 L=60e-9 MR=1
MNM_SE2 net26 SE net63 VPW nm1p2_svt_lp W=470e-9 L=60e-9 MR=1
MNM_SE1 net26 sen net22 VPW nm1p2_svt_lp W=470e-9 L=60e-9 MR=1
MNM2 SNN SN VSS VPW nm1p2_svt_lp W=230e-9 L=60e-9 MR=1
MNM1 ckb ckn VSS VPW nm1p2_svt_lp W=230e-9 L=60e-9 MR=1
MNM0 ckn CK VSS VPW nm1p2_svt_lp W=230e-9 L=60e-9 MR=1
MPM15 Q net52 VDD VNW pm1p2_svt_lp W=590e-9 L=60e-9 MR=1
MPM12 net46 ckb net60 VNW pm1p2_svt_lp W=150e-9 L=60e-9 MR=1
MPM11 net60 net52 VDD VNW pm1p2_svt_lp W=150e-9 L=60e-9 MR=1
MPM10 net52 net46 VDD VNW pm1p2_svt_lp W=590e-9 L=60e-9 MR=1
MPM9 net46 ckn net43 VNW pm1p2_svt_lp W=590e-9 L=60e-9 MR=1
MPM8 net34 ckn net62 VNW pm1p2_svt_lp W=150e-9 L=60e-9 MR=1
MPM7 net62 net43 VDD VNW pm1p2_svt_lp W=150e-9 L=60e-9 MR=1
MPM6 net43 net34 VDD VNW pm1p2_svt_lp W=410e-9 L=60e-9 MR=1
MPM4 net34 ckb net26 VNW pm1p2_svt_lp W=410e-9 L=60e-9 MR=1
MPM_SE0 sen SE VDD VNW pm1p2_svt_lp W=300e-9 L=60e-9 MR=1
MPMR3 net64 SI VDD VNW pm1p2_svt_lp W=590e-9 L=60e-9 MR=1
MPM_RN net22 RN VDD VNW pm1p2_svt_lp W=590e-9 L=60e-9 MR=1
MPM_SNN net65 SNN VDD VNW pm1p2_svt_lp W=590e-9 L=60e-9 MR=1
MPML3 net22 D net65 VNW pm1p2_svt_lp W=590e-9 L=60e-9 MR=1
MPM_SE2 net26 sen net64 VNW pm1p2_svt_lp W=390e-9 L=60e-9 MR=1
MPM_SE1 net26 SE net22 VNW pm1p2_svt_lp W=590e-9 L=60e-9 MR=1
MPM2 SNN SN VDD VNW pm1p2_svt_lp W=300e-9 L=60e-9 MR=1
MPM1 ckb ckn VDD VNW pm1p2_svt_lp W=300e-9 L=60e-9 MR=1
MPM0 ckn CK VDD VNW pm1p2_svt_lp W=300e-9 L=60e-9 MR=1
.ENDS
.SUBCKT SDFFKRSNQX2_9TSVT CK D Q RN SE SI SN VDD VSS VNW VPW
MNM15 Q net52 VSS VPW nm1p2_svt_lp W=940e-9 L=60e-9 MR=1
MNM11 net59 net52 VSS VPW nm1p2_svt_lp W=150e-9 L=60e-9 MR=1
MNM12 net46 ckn net59 VPW nm1p2_svt_lp W=150e-9 L=60e-9 MR=1
MNM10 net52 net46 VSS VPW nm1p2_svt_lp W=470e-9 L=60e-9 MR=1
MNM9 net46 ckb net43 VPW nm1p2_svt_lp W=470e-9 L=60e-9 MR=1
MNM7 net61 net43 VSS VPW nm1p2_svt_lp W=150e-9 L=60e-9 MR=1
MNM8 net34 ckb net61 VPW nm1p2_svt_lp W=150e-9 L=60e-9 MR=1
MNM6 net43 net34 VSS VPW nm1p2_svt_lp W=470e-9 L=60e-9 MR=1
MNM4 net34 ckn net26 VPW nm1p2_svt_lp W=470e-9 L=60e-9 MR=1
MNM_SE0 sen SE VSS VPW nm1p2_svt_lp W=230e-9 L=60e-9 MR=1
MNMR3 net63 SI VSS VPW nm1p2_svt_lp W=470e-9 L=60e-9 MR=1
MNM_SNN net22 SNN net17 VPW nm1p2_svt_lp W=470e-9 L=60e-9 MR=1
MNM_RN net17 RN VSS VPW nm1p2_svt_lp W=470e-9 L=60e-9 MR=1
MNML3 net22 D net17 VPW nm1p2_svt_lp W=470e-9 L=60e-9 MR=1
MNM_SE2 net26 SE net63 VPW nm1p2_svt_lp W=470e-9 L=60e-9 MR=1
MNM_SE1 net26 sen net22 VPW nm1p2_svt_lp W=470e-9 L=60e-9 MR=1
MNM2 SNN SN VSS VPW nm1p2_svt_lp W=230e-9 L=60e-9 MR=1
MNM1 ckb ckn VSS VPW nm1p2_svt_lp W=230e-9 L=60e-9 MR=1
MNM0 ckn CK VSS VPW nm1p2_svt_lp W=230e-9 L=60e-9 MR=1
MPM15 Q net52 VDD VNW pm1p2_svt_lp W=1.18e-6 L=60e-9 MR=1
MPM12 net46 ckb net60 VNW pm1p2_svt_lp W=150e-9 L=60e-9 MR=1
MPM11 net60 net52 VDD VNW pm1p2_svt_lp W=150e-9 L=60e-9 MR=1
MPM10 net52 net46 VDD VNW pm1p2_svt_lp W=590e-9 L=60e-9 MR=1
MPM9 net46 ckn net43 VNW pm1p2_svt_lp W=590e-9 L=60e-9 MR=1
MPM8 net34 ckn net62 VNW pm1p2_svt_lp W=150e-9 L=60e-9 MR=1
MPM7 net62 net43 VDD VNW pm1p2_svt_lp W=150e-9 L=60e-9 MR=1
MPM6 net43 net34 VDD VNW pm1p2_svt_lp W=410e-9 L=60e-9 MR=1
MPM4 net34 ckb net26 VNW pm1p2_svt_lp W=410e-9 L=60e-9 MR=1
MPM_SE0 sen SE VDD VNW pm1p2_svt_lp W=300e-9 L=60e-9 MR=1
MPMR3 net64 SI VDD VNW pm1p2_svt_lp W=590e-9 L=60e-9 MR=1
MPM_RN net22 RN VDD VNW pm1p2_svt_lp W=590e-9 L=60e-9 MR=1
MPM_SNN net65 SNN VDD VNW pm1p2_svt_lp W=590e-9 L=60e-9 MR=1
MPML3 net22 D net65 VNW pm1p2_svt_lp W=590e-9 L=60e-9 MR=1
MPM_SE2 net26 sen net64 VNW pm1p2_svt_lp W=390e-9 L=60e-9 MR=1
MPM_SE1 net26 SE net22 VNW pm1p2_svt_lp W=590e-9 L=60e-9 MR=1
MPM2 SNN SN VDD VNW pm1p2_svt_lp W=300e-9 L=60e-9 MR=1
MPM1 ckb ckn VDD VNW pm1p2_svt_lp W=300e-9 L=60e-9 MR=1
MPM0 ckn CK VDD VNW pm1p2_svt_lp W=300e-9 L=60e-9 MR=1
.ENDS
.SUBCKT SDFFKRSNQX4_9TSVT CK D Q RN SE SI SN VDD VSS VNW VPW
MNM15 Q net52 VSS VPW nm1p2_svt_lp W=1.88e-6 L=60e-9 MR=1
MNM11 net59 net52 VSS VPW nm1p2_svt_lp W=150e-9 L=60e-9 MR=1
MNM12 net46 ckn net59 VPW nm1p2_svt_lp W=150e-9 L=60e-9 MR=1
MNM10 net52 net46 VSS VPW nm1p2_svt_lp W=940e-9 L=60e-9 MR=1
MNM9 net46 ckb net43 VPW nm1p2_svt_lp W=470e-9 L=60e-9 MR=1
MNM7 net61 net43 VSS VPW nm1p2_svt_lp W=150e-9 L=60e-9 MR=1
MNM8 net34 ckb net61 VPW nm1p2_svt_lp W=150e-9 L=60e-9 MR=1
MNM6 net43 net34 VSS VPW nm1p2_svt_lp W=470e-9 L=60e-9 MR=1
MNM4 net34 ckn net26 VPW nm1p2_svt_lp W=470e-9 L=60e-9 MR=1
MNM_SE0 sen SE VSS VPW nm1p2_svt_lp W=230e-9 L=60e-9 MR=1
MNMR3 net63 SI VSS VPW nm1p2_svt_lp W=470e-9 L=60e-9 MR=1
MNM_SNN net22 SNN net17 VPW nm1p2_svt_lp W=470e-9 L=60e-9 MR=1
MNM_RN net17 RN VSS VPW nm1p2_svt_lp W=470e-9 L=60e-9 MR=1
MNML3 net22 D net17 VPW nm1p2_svt_lp W=470e-9 L=60e-9 MR=1
MNM_SE2 net26 SE net63 VPW nm1p2_svt_lp W=470e-9 L=60e-9 MR=1
MNM_SE1 net26 sen net22 VPW nm1p2_svt_lp W=470e-9 L=60e-9 MR=1
MNM2 SNN SN VSS VPW nm1p2_svt_lp W=230e-9 L=60e-9 MR=1
MNM1 ckb ckn VSS VPW nm1p2_svt_lp W=470e-9 L=60e-9 MR=1
MNM0 ckn CK VSS VPW nm1p2_svt_lp W=470e-9 L=60e-9 MR=1
MPM15 Q net52 VDD VNW pm1p2_svt_lp W=2.36e-6 L=60e-9 MR=1
MPM12 net46 ckb net60 VNW pm1p2_svt_lp W=150e-9 L=60e-9 MR=1
MPM11 net60 net52 VDD VNW pm1p2_svt_lp W=150e-9 L=60e-9 MR=1
MPM10 net52 net46 VDD VNW pm1p2_svt_lp W=1.18e-6 L=60e-9 MR=1
MPM9 net46 ckn net43 VNW pm1p2_svt_lp W=590e-9 L=60e-9 MR=1
MPM8 net34 ckn net62 VNW pm1p2_svt_lp W=150e-9 L=60e-9 MR=1
MPM7 net62 net43 VDD VNW pm1p2_svt_lp W=150e-9 L=60e-9 MR=1
MPM6 net43 net34 VDD VNW pm1p2_svt_lp W=410e-9 L=60e-9 MR=1
MPM4 net34 ckb net26 VNW pm1p2_svt_lp W=410e-9 L=60e-9 MR=1
MPM_SE0 sen SE VDD VNW pm1p2_svt_lp W=300e-9 L=60e-9 MR=1
MPMR3 net64 SI VDD VNW pm1p2_svt_lp W=590e-9 L=60e-9 MR=1
MPM_RN net22 RN VDD VNW pm1p2_svt_lp W=590e-9 L=60e-9 MR=1
MPM_SNN net65 SNN VDD VNW pm1p2_svt_lp W=590e-9 L=60e-9 MR=1
MPML3 net22 D net65 VNW pm1p2_svt_lp W=590e-9 L=60e-9 MR=1
MPM_SE2 net26 sen net64 VNW pm1p2_svt_lp W=390e-9 L=60e-9 MR=1
MPM_SE1 net26 SE net22 VNW pm1p2_svt_lp W=590e-9 L=60e-9 MR=1
MPM2 SNN SN VDD VNW pm1p2_svt_lp W=300e-9 L=60e-9 MR=1
MPM1 ckb ckn VDD VNW pm1p2_svt_lp W=590e-9 L=60e-9 MR=1
MPM0 ckn CK VDD VNW pm1p2_svt_lp W=390e-9 L=60e-9 MR=1
.ENDS
.SUBCKT SDFFKSNQX0P5_9TSVT CK D Q SE SI SN VDD VSS VNW VPW
MNM15 Q net46 VSS VPW nm1p2_svt_lp W=230e-9 L=60e-9 MR=1
MNM11 net53 net46 VSS VPW nm1p2_svt_lp W=150e-9 L=60e-9 MR=1
MNM12 net40 ckn net53 VPW nm1p2_svt_lp W=150e-9 L=60e-9 MR=1
MNM10 net46 net40 VSS VPW nm1p2_svt_lp W=230e-9 L=60e-9 MR=1
MNM9 net40 ckb net37 VPW nm1p2_svt_lp W=230e-9 L=60e-9 MR=1
MNM7 net55 net37 VSS VPW nm1p2_svt_lp W=150e-9 L=60e-9 MR=1
MNM8 net28 ckb net55 VPW nm1p2_svt_lp W=150e-9 L=60e-9 MR=1
MNM6 net37 net28 VSS VPW nm1p2_svt_lp W=230e-9 L=60e-9 MR=1
MNM4 net28 ckn net20 VPW nm1p2_svt_lp W=230e-9 L=60e-9 MR=1
MNM_SE0 sen SE VSS VPW nm1p2_svt_lp W=230e-9 L=60e-9 MR=1
MNMR3 net57 SI VSS VPW nm1p2_svt_lp W=230e-9 L=60e-9 MR=1
MNM_SNN net15 SNN VSS VPW nm1p2_svt_lp W=230e-9 L=60e-9 MR=1
MNML3 net15 D VSS VPW nm1p2_svt_lp W=230e-9 L=60e-9 MR=1
MNM_SE2 net20 SE net57 VPW nm1p2_svt_lp W=230e-9 L=60e-9 MR=1
MNM_SE1 net20 sen net15 VPW nm1p2_svt_lp W=230e-9 L=60e-9 MR=1
MNM2 SNN SN VSS VPW nm1p2_svt_lp W=230e-9 L=60e-9 MR=1
MNM1 ckb ckn VSS VPW nm1p2_svt_lp W=230e-9 L=60e-9 MR=1
MNM0 ckn CK VSS VPW nm1p2_svt_lp W=230e-9 L=60e-9 MR=1
MPM15 Q net46 VDD VNW pm1p2_svt_lp W=300e-9 L=60e-9 MR=1
MPM12 net40 ckb net54 VNW pm1p2_svt_lp W=150e-9 L=60e-9 MR=1
MPM11 net54 net46 VDD VNW pm1p2_svt_lp W=150e-9 L=60e-9 MR=1
MPM10 net46 net40 VDD VNW pm1p2_svt_lp W=300e-9 L=60e-9 MR=1
MPM9 net40 ckn net37 VNW pm1p2_svt_lp W=300e-9 L=60e-9 MR=1
MPM8 net28 ckn net56 VNW pm1p2_svt_lp W=150e-9 L=60e-9 MR=1
MPM7 net56 net37 VDD VNW pm1p2_svt_lp W=150e-9 L=60e-9 MR=1
MPM6 net37 net28 VDD VNW pm1p2_svt_lp W=300e-9 L=60e-9 MR=1
MPM4 net28 ckb net20 VNW pm1p2_svt_lp W=300e-9 L=60e-9 MR=1
MPM_SE0 sen SE VDD VNW pm1p2_svt_lp W=300e-9 L=60e-9 MR=1
MPMR3 net58 SI VDD VNW pm1p2_svt_lp W=300e-9 L=60e-9 MR=1
MPM_SNN net60 SNN VDD VNW pm1p2_svt_lp W=300e-9 L=60e-9 MR=1
MPML3 net59 D net60 VNW pm1p2_svt_lp W=300e-9 L=60e-9 MR=1
MPM_SE2 net20 sen net58 VNW pm1p2_svt_lp W=300e-9 L=60e-9 MR=1
MPM_SE1 net20 SE net59 VNW pm1p2_svt_lp W=300e-9 L=60e-9 MR=1
MPM2 SNN SN VDD VNW pm1p2_svt_lp W=300e-9 L=60e-9 MR=1
MPM1 ckb ckn VDD VNW pm1p2_svt_lp W=300e-9 L=60e-9 MR=1
MPM0 ckn CK VDD VNW pm1p2_svt_lp W=300e-9 L=60e-9 MR=1
.ENDS
.SUBCKT SDFFKSNQX1_9TSVT CK D Q SE SI SN VDD VSS VNW VPW
MNM15 Q net46 VSS VPW nm1p2_svt_lp W=470e-9 L=60e-9 MR=1
MNM11 net53 net46 VSS VPW nm1p2_svt_lp W=150e-9 L=60e-9 MR=1
MNM12 net40 ckn net53 VPW nm1p2_svt_lp W=150e-9 L=60e-9 MR=1
MNM10 net46 net40 VSS VPW nm1p2_svt_lp W=470e-9 L=60e-9 MR=1
MNM9 net40 ckb net37 VPW nm1p2_svt_lp W=470e-9 L=60e-9 MR=1
MNM7 net55 net37 VSS VPW nm1p2_svt_lp W=150e-9 L=60e-9 MR=1
MNM8 net28 ckb net55 VPW nm1p2_svt_lp W=150e-9 L=60e-9 MR=1
MNM6 net37 net28 VSS VPW nm1p2_svt_lp W=470e-9 L=60e-9 MR=1
MNM4 net28 ckn net20 VPW nm1p2_svt_lp W=470e-9 L=60e-9 MR=1
MNM_SE0 sen SE VSS VPW nm1p2_svt_lp W=230e-9 L=60e-9 MR=1
MNMR3 net57 SI VSS VPW nm1p2_svt_lp W=470e-9 L=60e-9 MR=1
MNM_SNN net15 SNN VSS VPW nm1p2_svt_lp W=470e-9 L=60e-9 MR=1
MNML3 net15 D VSS VPW nm1p2_svt_lp W=470e-9 L=60e-9 MR=1
MNM_SE2 net20 SE net57 VPW nm1p2_svt_lp W=470e-9 L=60e-9 MR=1
MNM_SE1 net20 sen net15 VPW nm1p2_svt_lp W=320e-9 L=60e-9 MR=1
MNM2 SNN SN VSS VPW nm1p2_svt_lp W=230e-9 L=60e-9 MR=1
MNM1 ckb ckn VSS VPW nm1p2_svt_lp W=230e-9 L=60e-9 MR=1
MNM0 ckn CK VSS VPW nm1p2_svt_lp W=230e-9 L=60e-9 MR=1
MPM15 Q net46 VDD VNW pm1p2_svt_lp W=590e-9 L=60e-9 MR=1
MPM12 net40 ckb net54 VNW pm1p2_svt_lp W=150e-9 L=60e-9 MR=1
MPM11 net54 net46 VDD VNW pm1p2_svt_lp W=150e-9 L=60e-9 MR=1
MPM10 net46 net40 VDD VNW pm1p2_svt_lp W=590e-9 L=60e-9 MR=1
MPM9 net40 ckn net37 VNW pm1p2_svt_lp W=590e-9 L=60e-9 MR=1
MPM8 net28 ckn net56 VNW pm1p2_svt_lp W=150e-9 L=60e-9 MR=1
MPM7 net56 net37 VDD VNW pm1p2_svt_lp W=150e-9 L=60e-9 MR=1
MPM6 net37 net28 VDD VNW pm1p2_svt_lp W=590e-9 L=60e-9 MR=1
MPM4 net28 ckb net20 VNW pm1p2_svt_lp W=590e-9 L=60e-9 MR=1
MPM_SE0 sen SE VDD VNW pm1p2_svt_lp W=300e-9 L=60e-9 MR=1
MPMR3 net58 SI VDD VNW pm1p2_svt_lp W=360e-9 L=60e-9 MR=1
MPM_SNN net60 SNN VDD VNW pm1p2_svt_lp W=390e-9 L=60e-9 MR=1
MPML3 net59 D net60 VNW pm1p2_svt_lp W=390e-9 L=60e-9 MR=1
MPM_SE2 net20 sen net58 VNW pm1p2_svt_lp W=360e-9 L=60e-9 MR=1
MPM_SE1 net20 SE net59 VNW pm1p2_svt_lp W=360e-9 L=60e-9 MR=1
MPM2 SNN SN VDD VNW pm1p2_svt_lp W=300e-9 L=60e-9 MR=1
MPM1 ckb ckn VDD VNW pm1p2_svt_lp W=300e-9 L=60e-9 MR=1
MPM0 ckn CK VDD VNW pm1p2_svt_lp W=300e-9 L=60e-9 MR=1
.ENDS
.SUBCKT SDFFKSNQX2_9TSVT CK D Q SE SI SN VDD VSS VNW VPW
MNM15 Q net46 VSS VPW nm1p2_svt_lp W=940e-9 L=60e-9 MR=1
MNM11 net53 net46 VSS VPW nm1p2_svt_lp W=150e-9 L=60e-9 MR=1
MNM12 net40 ckn net53 VPW nm1p2_svt_lp W=150e-9 L=60e-9 MR=1
MNM10 net46 net40 VSS VPW nm1p2_svt_lp W=470e-9 L=60e-9 MR=1
MNM9 net40 ckb net37 VPW nm1p2_svt_lp W=470e-9 L=60e-9 MR=1
MNM7 net55 net37 VSS VPW nm1p2_svt_lp W=150e-9 L=60e-9 MR=1
MNM8 net28 ckb net55 VPW nm1p2_svt_lp W=150e-9 L=60e-9 MR=1
MNM6 net37 net28 VSS VPW nm1p2_svt_lp W=470e-9 L=60e-9 MR=1
MNM4 net28 ckn net20 VPW nm1p2_svt_lp W=470e-9 L=60e-9 MR=1
MNM_SE0 sen SE VSS VPW nm1p2_svt_lp W=230e-9 L=60e-9 MR=1
MNMR3 net57 SI VSS VPW nm1p2_svt_lp W=470e-9 L=60e-9 MR=1
MNM_SNN net15 SNN VSS VPW nm1p2_svt_lp W=470e-9 L=60e-9 MR=1
MNML3 net15 D VSS VPW nm1p2_svt_lp W=470e-9 L=60e-9 MR=1
MNM_SE2 net20 SE net57 VPW nm1p2_svt_lp W=470e-9 L=60e-9 MR=1
MNM_SE1 net20 sen net15 VPW nm1p2_svt_lp W=320e-9 L=60e-9 MR=1
MNM2 SNN SN VSS VPW nm1p2_svt_lp W=230e-9 L=60e-9 MR=1
MNM1 ckb ckn VSS VPW nm1p2_svt_lp W=230e-9 L=60e-9 MR=1
MNM0 ckn CK VSS VPW nm1p2_svt_lp W=230e-9 L=60e-9 MR=1
MPM15 Q net46 VDD VNW pm1p2_svt_lp W=1.18e-6 L=60e-9 MR=1
MPM12 net40 ckb net54 VNW pm1p2_svt_lp W=150e-9 L=60e-9 MR=1
MPM11 net54 net46 VDD VNW pm1p2_svt_lp W=150e-9 L=60e-9 MR=1
MPM10 net46 net40 VDD VNW pm1p2_svt_lp W=590e-9 L=60e-9 MR=1
MPM9 net40 ckn net37 VNW pm1p2_svt_lp W=590e-9 L=60e-9 MR=1
MPM8 net28 ckn net56 VNW pm1p2_svt_lp W=150e-9 L=60e-9 MR=1
MPM7 net56 net37 VDD VNW pm1p2_svt_lp W=150e-9 L=60e-9 MR=1
MPM6 net37 net28 VDD VNW pm1p2_svt_lp W=410e-9 L=60e-9 MR=1
MPM4 net28 ckb net20 VNW pm1p2_svt_lp W=410e-9 L=60e-9 MR=1
MPM_SE0 sen SE VDD VNW pm1p2_svt_lp W=300e-9 L=60e-9 MR=1
MPMR3 net58 SI VDD VNW pm1p2_svt_lp W=360e-9 L=60e-9 MR=1
MPM_SNN net60 SNN VDD VNW pm1p2_svt_lp W=390e-9 L=60e-9 MR=1
MPML3 net59 D net60 VNW pm1p2_svt_lp W=390e-9 L=60e-9 MR=1
MPM_SE2 net20 sen net58 VNW pm1p2_svt_lp W=360e-9 L=60e-9 MR=1
MPM_SE1 net20 SE net59 VNW pm1p2_svt_lp W=360e-9 L=60e-9 MR=1
MPM2 SNN SN VDD VNW pm1p2_svt_lp W=300e-9 L=60e-9 MR=1
MPM1 ckb ckn VDD VNW pm1p2_svt_lp W=300e-9 L=60e-9 MR=1
MPM0 ckn CK VDD VNW pm1p2_svt_lp W=300e-9 L=60e-9 MR=1
.ENDS
.SUBCKT SDFFKSNQX4_9TSVT CK D Q SE SI SN VDD VSS VNW VPW
MNM15 Q net46 VSS VPW nm1p2_svt_lp W=1.88e-6 L=60e-9 MR=1
MNM11 net53 net46 VSS VPW nm1p2_svt_lp W=150e-9 L=60e-9 MR=1
MNM12 net40 ckn net53 VPW nm1p2_svt_lp W=150e-9 L=60e-9 MR=1
MNM10 net46 net40 VSS VPW nm1p2_svt_lp W=940e-9 L=60e-9 MR=1
MNM9 net40 ckb net37 VPW nm1p2_svt_lp W=470e-9 L=60e-9 MR=1
MNM7 net55 net37 VSS VPW nm1p2_svt_lp W=150e-9 L=60e-9 MR=1
MNM8 net28 ckb net55 VPW nm1p2_svt_lp W=150e-9 L=60e-9 MR=1
MNM6 net37 net28 VSS VPW nm1p2_svt_lp W=470e-9 L=60e-9 MR=1
MNM4 net28 ckn net20 VPW nm1p2_svt_lp W=470e-9 L=60e-9 MR=1
MNM_SE0 sen SE VSS VPW nm1p2_svt_lp W=230e-9 L=60e-9 MR=1
MNMR3 net57 SI VSS VPW nm1p2_svt_lp W=470e-9 L=60e-9 MR=1
MNM_SNN net15 SNN VSS VPW nm1p2_svt_lp W=470e-9 L=60e-9 MR=1
MNML3 net15 D VSS VPW nm1p2_svt_lp W=470e-9 L=60e-9 MR=1
MNM_SE2 net20 SE net57 VPW nm1p2_svt_lp W=470e-9 L=60e-9 MR=1
MNM_SE1 net20 sen net15 VPW nm1p2_svt_lp W=320e-9 L=60e-9 MR=1
MNM2 SNN SN VSS VPW nm1p2_svt_lp W=230e-9 L=60e-9 MR=1
MNM1 ckb ckn VSS VPW nm1p2_svt_lp W=470e-9 L=60e-9 MR=1
MNM0 ckn CK VSS VPW nm1p2_svt_lp W=470e-9 L=60e-9 MR=1
MPM15 Q net46 VDD VNW pm1p2_svt_lp W=2.36e-6 L=60e-9 MR=1
MPM12 net40 ckb net54 VNW pm1p2_svt_lp W=150e-9 L=60e-9 MR=1
MPM11 net54 net46 VDD VNW pm1p2_svt_lp W=150e-9 L=60e-9 MR=1
MPM10 net46 net40 VDD VNW pm1p2_svt_lp W=1.18e-6 L=60e-9 MR=1
MPM9 net40 ckn net37 VNW pm1p2_svt_lp W=590e-9 L=60e-9 MR=1
MPM8 net28 ckn net56 VNW pm1p2_svt_lp W=150e-9 L=60e-9 MR=1
MPM7 net56 net37 VDD VNW pm1p2_svt_lp W=150e-9 L=60e-9 MR=1
MPM6 net37 net28 VDD VNW pm1p2_svt_lp W=410e-9 L=60e-9 MR=1
MPM4 net28 ckb net20 VNW pm1p2_svt_lp W=410e-9 L=60e-9 MR=1
MPM_SE0 sen SE VDD VNW pm1p2_svt_lp W=300e-9 L=60e-9 MR=1
MPMR3 net58 SI VDD VNW pm1p2_svt_lp W=360e-9 L=60e-9 MR=1
MPM_SNN net60 SNN VDD VNW pm1p2_svt_lp W=390e-9 L=60e-9 MR=1
MPML3 net59 D net60 VNW pm1p2_svt_lp W=390e-9 L=60e-9 MR=1
MPM_SE2 net20 sen net58 VNW pm1p2_svt_lp W=360e-9 L=60e-9 MR=1
MPM_SE1 net20 SE net59 VNW pm1p2_svt_lp W=360e-9 L=60e-9 MR=1
MPM2 SNN SN VDD VNW pm1p2_svt_lp W=300e-9 L=60e-9 MR=1
MPM1 ckb ckn VDD VNW pm1p2_svt_lp W=590e-9 L=60e-9 MR=1
MPM0 ckn CK VDD VNW pm1p2_svt_lp W=390e-9 L=60e-9 MR=1
.ENDS
.SUBCKT SDFFNQX0P5_9TSVT CKN D Q SE SI VDD VSS VNW VPW
MNM11 Q net40 VSS VPW nm1p2_svt_lp W=230e-9 L=60e-9 MR=1
MNM9 net46 net40 VSS VPW nm1p2_svt_lp W=150e-9 L=60e-9 MR=1
MNM10 net34 ckb net46 VPW nm1p2_svt_lp W=150e-9 L=60e-9 MR=1
MNM8 net40 net34 VSS VPW nm1p2_svt_lp W=230e-9 L=60e-9 MR=1
MNM7 net34 cknn net31 VPW nm1p2_svt_lp W=230e-9 L=60e-9 MR=1
MNM5 net48 net31 VSS VPW nm1p2_svt_lp W=150e-9 L=60e-9 MR=1
MNM6 net22 cknn net48 VPW nm1p2_svt_lp W=150e-9 L=60e-9 MR=1
MNM4 net31 net22 VSS VPW nm1p2_svt_lp W=230e-9 L=60e-9 MR=1
MNM_SE0 sen SE VSS VPW nm1p2_svt_lp W=230e-9 L=60e-9 MR=1
MNMR2 net50 SI VSS VPW nm1p2_svt_lp W=230e-9 L=60e-9 MR=1
MNML2 net51 D VSS VPW nm1p2_svt_lp W=230e-9 L=60e-9 MR=1
MNM_SE2 net18 SE net50 VPW nm1p2_svt_lp W=230e-9 L=60e-9 MR=1
MNM_SE1 net18 sen net51 VPW nm1p2_svt_lp W=230e-9 L=60e-9 MR=1
MNM3 net22 ckb net18 VPW nm1p2_svt_lp W=230e-9 L=60e-9 MR=1
MNM1 ckb cknn VSS VPW nm1p2_svt_lp W=230e-9 L=60e-9 MR=1
MNM0 cknn CKN VSS VPW nm1p2_svt_lp W=230e-9 L=60e-9 MR=1
MPM11 Q net40 VDD VNW pm1p2_svt_lp W=300e-9 L=60e-9 MR=1
MPM10 net34 cknn net47 VNW pm1p2_svt_lp W=150e-9 L=60e-9 MR=1
MPM9 net47 net40 VDD VNW pm1p2_svt_lp W=150e-9 L=60e-9 MR=1
MPM8 net40 net34 VDD VNW pm1p2_svt_lp W=300e-9 L=60e-9 MR=1
MPM7 net34 ckb net31 VNW pm1p2_svt_lp W=300e-9 L=60e-9 MR=1
MPM6 net22 ckb net49 VNW pm1p2_svt_lp W=150e-9 L=60e-9 MR=1
MPM5 net49 net31 VDD VNW pm1p2_svt_lp W=150e-9 L=60e-9 MR=1
MPM4 net31 net22 VDD VNW pm1p2_svt_lp W=300e-9 L=60e-9 MR=1
MPM_SE0 sen SE VDD VNW pm1p2_svt_lp W=300e-9 L=60e-9 MR=1
MPM3 net22 cknn net18 VNW pm1p2_svt_lp W=300e-9 L=60e-9 MR=1
MPMR2 net52 SI VDD VNW pm1p2_svt_lp W=300e-9 L=60e-9 MR=1
MPML2 net53 D VDD VNW pm1p2_svt_lp W=300e-9 L=60e-9 MR=1
MPM_SE2 net18 sen net52 VNW pm1p2_svt_lp W=300e-9 L=60e-9 MR=1
MPM_SE1 net18 SE net53 VNW pm1p2_svt_lp W=300e-9 L=60e-9 MR=1
MPM1 ckb cknn VDD VNW pm1p2_svt_lp W=300e-9 L=60e-9 MR=1
MPM0 cknn CKN VDD VNW pm1p2_svt_lp W=300e-9 L=60e-9 MR=1
.ENDS
.SUBCKT SDFFNQX1_9TSVT CKN D Q SE SI VDD VSS VNW VPW
MNM11 Q net40 VSS VPW nm1p2_svt_lp W=470e-9 L=60e-9 MR=1
MNM9 net46 net40 VSS VPW nm1p2_svt_lp W=150e-9 L=60e-9 MR=1
MNM10 net34 ckb net46 VPW nm1p2_svt_lp W=150e-9 L=60e-9 MR=1
MNM8 net40 net34 VSS VPW nm1p2_svt_lp W=470e-9 L=60e-9 MR=1
MNM7 net34 cknn net31 VPW nm1p2_svt_lp W=470e-9 L=60e-9 MR=1
MNM5 net48 net31 VSS VPW nm1p2_svt_lp W=150e-9 L=60e-9 MR=1
MNM6 net22 cknn net48 VPW nm1p2_svt_lp W=150e-9 L=60e-9 MR=1
MNM4 net31 net22 VSS VPW nm1p2_svt_lp W=470e-9 L=60e-9 MR=1
MNM_SE0 sen SE VSS VPW nm1p2_svt_lp W=230e-9 L=60e-9 MR=1
MNMR2 net50 SI VSS VPW nm1p2_svt_lp W=470e-9 L=60e-9 MR=1
MNML2 net51 D VSS VPW nm1p2_svt_lp W=470e-9 L=60e-9 MR=1
MNM_SE2 net18 SE net50 VPW nm1p2_svt_lp W=470e-9 L=60e-9 MR=1
MNM_SE1 net18 sen net51 VPW nm1p2_svt_lp W=470e-9 L=60e-9 MR=1
MNM3 net22 ckb net18 VPW nm1p2_svt_lp W=470e-9 L=60e-9 MR=1
MNM1 ckb cknn VSS VPW nm1p2_svt_lp W=230e-9 L=60e-9 MR=1
MNM0 cknn CKN VSS VPW nm1p2_svt_lp W=230e-9 L=60e-9 MR=1
MPM11 Q net40 VDD VNW pm1p2_svt_lp W=590e-9 L=60e-9 MR=1
MPM10 net34 cknn net47 VNW pm1p2_svt_lp W=150e-9 L=60e-9 MR=1
MPM9 net47 net40 VDD VNW pm1p2_svt_lp W=150e-9 L=60e-9 MR=1
MPM8 net40 net34 VDD VNW pm1p2_svt_lp W=590e-9 L=60e-9 MR=1
MPM7 net34 ckb net31 VNW pm1p2_svt_lp W=590e-9 L=60e-9 MR=1
MPM6 net22 ckb net49 VNW pm1p2_svt_lp W=150e-9 L=60e-9 MR=1
MPM5 net49 net31 VDD VNW pm1p2_svt_lp W=150e-9 L=60e-9 MR=1
MPM4 net31 net22 VDD VNW pm1p2_svt_lp W=590e-9 L=60e-9 MR=1
MPM_SE0 sen SE VDD VNW pm1p2_svt_lp W=300e-9 L=60e-9 MR=1
MPM3 net22 cknn net18 VNW pm1p2_svt_lp W=590e-9 L=60e-9 MR=1
MPMR2 net52 SI VDD VNW pm1p2_svt_lp W=590e-9 L=60e-9 MR=1
MPML2 net53 D VDD VNW pm1p2_svt_lp W=590e-9 L=60e-9 MR=1
MPM_SE2 net18 sen net52 VNW pm1p2_svt_lp W=590e-9 L=60e-9 MR=1
MPM_SE1 net18 SE net53 VNW pm1p2_svt_lp W=590e-9 L=60e-9 MR=1
MPM1 ckb cknn VDD VNW pm1p2_svt_lp W=300e-9 L=60e-9 MR=1
MPM0 cknn CKN VDD VNW pm1p2_svt_lp W=300e-9 L=60e-9 MR=1
.ENDS
.SUBCKT SDFFNQX2_9TSVT CKN D Q SE SI VDD VSS VNW VPW
MNM11 Q net40 VSS VPW nm1p2_svt_lp W=940e-9 L=60e-9 MR=1
MNM9 net46 net40 VSS VPW nm1p2_svt_lp W=150e-9 L=60e-9 MR=1
MNM10 net34 ckb net46 VPW nm1p2_svt_lp W=150e-9 L=60e-9 MR=1
MNM8 net40 net34 VSS VPW nm1p2_svt_lp W=470e-9 L=60e-9 MR=1
MNM7 net34 cknn net31 VPW nm1p2_svt_lp W=470e-9 L=60e-9 MR=1
MNM5 net48 net31 VSS VPW nm1p2_svt_lp W=150e-9 L=60e-9 MR=1
MNM6 net22 cknn net48 VPW nm1p2_svt_lp W=150e-9 L=60e-9 MR=1
MNM4 net31 net22 VSS VPW nm1p2_svt_lp W=470e-9 L=60e-9 MR=1
MNM_SE0 sen SE VSS VPW nm1p2_svt_lp W=230e-9 L=60e-9 MR=1
MNMR2 net50 SI VSS VPW nm1p2_svt_lp W=470e-9 L=60e-9 MR=1
MNML2 net51 D VSS VPW nm1p2_svt_lp W=470e-9 L=60e-9 MR=1
MNM_SE2 net18 SE net50 VPW nm1p2_svt_lp W=470e-9 L=60e-9 MR=1
MNM_SE1 net18 sen net51 VPW nm1p2_svt_lp W=470e-9 L=60e-9 MR=1
MNM3 net22 ckb net18 VPW nm1p2_svt_lp W=470e-9 L=60e-9 MR=1
MNM1 ckb cknn VSS VPW nm1p2_svt_lp W=230e-9 L=60e-9 MR=1
MNM0 cknn CKN VSS VPW nm1p2_svt_lp W=230e-9 L=60e-9 MR=1
MPM11 Q net40 VDD VNW pm1p2_svt_lp W=1.18e-6 L=60e-9 MR=1
MPM10 net34 cknn net47 VNW pm1p2_svt_lp W=150e-9 L=60e-9 MR=1
MPM9 net47 net40 VDD VNW pm1p2_svt_lp W=150e-9 L=60e-9 MR=1
MPM8 net40 net34 VDD VNW pm1p2_svt_lp W=590e-9 L=60e-9 MR=1
MPM7 net34 ckb net31 VNW pm1p2_svt_lp W=590e-9 L=60e-9 MR=1
MPM6 net22 ckb net49 VNW pm1p2_svt_lp W=150e-9 L=60e-9 MR=1
MPM5 net49 net31 VDD VNW pm1p2_svt_lp W=150e-9 L=60e-9 MR=1
MPM4 net31 net22 VDD VNW pm1p2_svt_lp W=590e-9 L=60e-9 MR=1
MPM_SE0 sen SE VDD VNW pm1p2_svt_lp W=300e-9 L=60e-9 MR=1
MPM3 net22 cknn net18 VNW pm1p2_svt_lp W=590e-9 L=60e-9 MR=1
MPMR2 net52 SI VDD VNW pm1p2_svt_lp W=590e-9 L=60e-9 MR=1
MPML2 net53 D VDD VNW pm1p2_svt_lp W=590e-9 L=60e-9 MR=1
MPM_SE2 net18 sen net52 VNW pm1p2_svt_lp W=590e-9 L=60e-9 MR=1
MPM_SE1 net18 SE net53 VNW pm1p2_svt_lp W=590e-9 L=60e-9 MR=1
MPM1 ckb cknn VDD VNW pm1p2_svt_lp W=300e-9 L=60e-9 MR=1
MPM0 cknn CKN VDD VNW pm1p2_svt_lp W=300e-9 L=60e-9 MR=1
.ENDS
.SUBCKT SDFFNQX4_9TSVT CKN D Q SE SI VDD VSS VNW VPW
MNM11 Q net40 VSS VPW nm1p2_svt_lp W=1.88e-6 L=60e-9 MR=1
MNM9 net46 net40 VSS VPW nm1p2_svt_lp W=150e-9 L=60e-9 MR=1
MNM10 net34 ckb net46 VPW nm1p2_svt_lp W=150e-9 L=60e-9 MR=1
MNM8 net40 net34 VSS VPW nm1p2_svt_lp W=940e-9 L=60e-9 MR=1
MNM7 net34 cknn net31 VPW nm1p2_svt_lp W=470e-9 L=60e-9 MR=1
MNM5 net48 net31 VSS VPW nm1p2_svt_lp W=150e-9 L=60e-9 MR=1
MNM6 net22 cknn net48 VPW nm1p2_svt_lp W=150e-9 L=60e-9 MR=1
MNM4 net31 net22 VSS VPW nm1p2_svt_lp W=470e-9 L=60e-9 MR=1
MNM_SE0 sen SE VSS VPW nm1p2_svt_lp W=230e-9 L=60e-9 MR=1
MNMR2 net50 SI VSS VPW nm1p2_svt_lp W=470e-9 L=60e-9 MR=1
MNML2 net51 D VSS VPW nm1p2_svt_lp W=470e-9 L=60e-9 MR=1
MNM_SE2 net18 SE net50 VPW nm1p2_svt_lp W=470e-9 L=60e-9 MR=1
MNM_SE1 net18 sen net51 VPW nm1p2_svt_lp W=470e-9 L=60e-9 MR=1
MNM3 net22 ckb net18 VPW nm1p2_svt_lp W=470e-9 L=60e-9 MR=1
MNM1 ckb cknn VSS VPW nm1p2_svt_lp W=270e-9 L=60e-9 MR=1
MNM0 cknn CKN VSS VPW nm1p2_svt_lp W=470e-9 L=60e-9 MR=1
MPM11 Q net40 VDD VNW pm1p2_svt_lp W=2.36e-6 L=60e-9 MR=1
MPM10 net34 cknn net47 VNW pm1p2_svt_lp W=150e-9 L=60e-9 MR=1
MPM9 net47 net40 VDD VNW pm1p2_svt_lp W=150e-9 L=60e-9 MR=1
MPM8 net40 net34 VDD VNW pm1p2_svt_lp W=1.18e-6 L=60e-9 MR=1
MPM7 net34 ckb net31 VNW pm1p2_svt_lp W=590e-9 L=60e-9 MR=1
MPM6 net22 ckb net49 VNW pm1p2_svt_lp W=150e-9 L=60e-9 MR=1
MPM5 net49 net31 VDD VNW pm1p2_svt_lp W=150e-9 L=60e-9 MR=1
MPM4 net31 net22 VDD VNW pm1p2_svt_lp W=590e-9 L=60e-9 MR=1
MPM_SE0 sen SE VDD VNW pm1p2_svt_lp W=300e-9 L=60e-9 MR=1
MPM3 net22 cknn net18 VNW pm1p2_svt_lp W=590e-9 L=60e-9 MR=1
MPMR2 net52 SI VDD VNW pm1p2_svt_lp W=590e-9 L=60e-9 MR=1
MPML2 net53 D VDD VNW pm1p2_svt_lp W=590e-9 L=60e-9 MR=1
MPM_SE2 net18 sen net52 VNW pm1p2_svt_lp W=590e-9 L=60e-9 MR=1
MPM_SE1 net18 SE net53 VNW pm1p2_svt_lp W=590e-9 L=60e-9 MR=1
MPM1 ckb cknn VDD VNW pm1p2_svt_lp W=590e-9 L=60e-9 MR=1
MPM0 cknn CKN VDD VNW pm1p2_svt_lp W=590e-9 L=60e-9 MR=1
.ENDS
.SUBCKT SDFFNRNQX0P5_9TSVT CKN D Q RN SE SI VDD VSS VNW VPW
MNM11 Q net39 VSS VPW nm1p2_svt_lp W=230e-9 L=60e-9 MR=1
MNM9 net51 net39 VSS VPW nm1p2_svt_lp W=150e-9 L=60e-9 MR=1
MNM10 net36 ckb net51 VPW nm1p2_svt_lp W=150e-9 L=60e-9 MR=1
MNM_RN2 net53 RN VSS VPW nm1p2_svt_lp W=230e-9 L=60e-9 MR=1
MNM8 net39 net36 net53 VPW nm1p2_svt_lp W=230e-9 L=60e-9 MR=1
MNM7 net36 cknn net33 VPW nm1p2_svt_lp W=230e-9 L=60e-9 MR=1
MNM_RN net54 RN VSS VPW nm1p2_svt_lp W=150e-9 L=60e-9 MR=1
MNM5 net55 net33 net54 VPW nm1p2_svt_lp W=150e-9 L=60e-9 MR=1
MNM6 net24 cknn net55 VPW nm1p2_svt_lp W=150e-9 L=60e-9 MR=1
MNM4 net33 net24 VSS VPW nm1p2_svt_lp W=230e-9 L=60e-9 MR=1
MNM_SE0 sen SE VSS VPW nm1p2_svt_lp W=230e-9 L=60e-9 MR=1
MNMR2 net56 SI VSS VPW nm1p2_svt_lp W=230e-9 L=60e-9 MR=1
MNML2 net57 D VSS VPW nm1p2_svt_lp W=230e-9 L=60e-9 MR=1
MNM_SE2 net20 SE net56 VPW nm1p2_svt_lp W=230e-9 L=60e-9 MR=1
MNM_SE1 net20 sen net57 VPW nm1p2_svt_lp W=230e-9 L=60e-9 MR=1
MNM3 net24 ckb net20 VPW nm1p2_svt_lp W=230e-9 L=60e-9 MR=1
MNM1 ckb cknn VSS VPW nm1p2_svt_lp W=230e-9 L=60e-9 MR=1
MNM0 cknn CKN VSS VPW nm1p2_svt_lp W=230e-9 L=60e-9 MR=1
MPM11 Q net39 VDD VNW pm1p2_svt_lp W=300e-9 L=60e-9 MR=1
MPM10 net36 cknn net52 VNW pm1p2_svt_lp W=150e-9 L=60e-9 MR=1
MPM9 net52 net39 VDD VNW pm1p2_svt_lp W=150e-9 L=60e-9 MR=1
MPM_RN2 net39 RN VDD VNW pm1p2_svt_lp W=300e-9 L=60e-9 MR=1
MPM8 net39 net36 VDD VNW pm1p2_svt_lp W=300e-9 L=60e-9 MR=1
MPM7 net36 ckb net33 VNW pm1p2_svt_lp W=300e-9 L=60e-9 MR=1
MPM6 net24 ckb net46 VNW pm1p2_svt_lp W=150e-9 L=60e-9 MR=1
MPM_RN net46 RN VDD VNW pm1p2_svt_lp W=150e-9 L=60e-9 MR=1
MPM5 net46 net33 VDD VNW pm1p2_svt_lp W=150e-9 L=60e-9 MR=1
MPM4 net33 net24 VDD VNW pm1p2_svt_lp W=300e-9 L=60e-9 MR=1
MPM_SE0 sen SE VDD VNW pm1p2_svt_lp W=300e-9 L=60e-9 MR=1
MPM3 net24 cknn net20 VNW pm1p2_svt_lp W=300e-9 L=60e-9 MR=1
MPMR2 net58 SI VDD VNW pm1p2_svt_lp W=300e-9 L=60e-9 MR=1
MPML2 net59 D VDD VNW pm1p2_svt_lp W=300e-9 L=60e-9 MR=1
MPM_SE2 net20 sen net58 VNW pm1p2_svt_lp W=300e-9 L=60e-9 MR=1
MPM_SE1 net20 SE net59 VNW pm1p2_svt_lp W=300e-9 L=60e-9 MR=1
MPM1 ckb cknn VDD VNW pm1p2_svt_lp W=300e-9 L=60e-9 MR=1
MPM0 cknn CKN VDD VNW pm1p2_svt_lp W=300e-9 L=60e-9 MR=1
.ENDS
.SUBCKT SDFFNRNQX1_9TSVT CKN D Q RN SE SI VDD VSS VNW VPW
MNM11 Q net39 VSS VPW nm1p2_svt_lp W=470e-9 L=60e-9 MR=1
MNM9 net51 net39 VSS VPW nm1p2_svt_lp W=150e-9 L=60e-9 MR=1
MNM10 net36 ckb net51 VPW nm1p2_svt_lp W=150e-9 L=60e-9 MR=1
MNM_RN2 net53 RN VSS VPW nm1p2_svt_lp W=470e-9 L=60e-9 MR=1
MNM8 net39 net36 net53 VPW nm1p2_svt_lp W=470e-9 L=60e-9 MR=1
MNM7 net36 cknn net33 VPW nm1p2_svt_lp W=470e-9 L=60e-9 MR=1
MNM_RN net54 RN VSS VPW nm1p2_svt_lp W=150e-9 L=60e-9 MR=1
MNM5 net55 net33 net54 VPW nm1p2_svt_lp W=150e-9 L=60e-9 MR=1
MNM6 net24 cknn net55 VPW nm1p2_svt_lp W=150e-9 L=60e-9 MR=1
MNM4 net33 net24 VSS VPW nm1p2_svt_lp W=470e-9 L=60e-9 MR=1
MNM_SE0 sen SE VSS VPW nm1p2_svt_lp W=230e-9 L=60e-9 MR=1
MNMR2 net56 SI VSS VPW nm1p2_svt_lp W=470e-9 L=60e-9 MR=1
MNML2 net57 D VSS VPW nm1p2_svt_lp W=470e-9 L=60e-9 MR=1
MNM_SE2 net20 SE net56 VPW nm1p2_svt_lp W=470e-9 L=60e-9 MR=1
MNM_SE1 net20 sen net57 VPW nm1p2_svt_lp W=470e-9 L=60e-9 MR=1
MNM3 net24 ckb net20 VPW nm1p2_svt_lp W=470e-9 L=60e-9 MR=1
MNM1 ckb cknn VSS VPW nm1p2_svt_lp W=230e-9 L=60e-9 MR=1
MNM0 cknn CKN VSS VPW nm1p2_svt_lp W=230e-9 L=60e-9 MR=1
MPM11 Q net39 VDD VNW pm1p2_svt_lp W=590e-9 L=60e-9 MR=1
MPM10 net36 cknn net52 VNW pm1p2_svt_lp W=150e-9 L=60e-9 MR=1
MPM9 net52 net39 VDD VNW pm1p2_svt_lp W=150e-9 L=60e-9 MR=1
MPM_RN2 net39 RN VDD VNW pm1p2_svt_lp W=590e-9 L=60e-9 MR=1
MPM8 net39 net36 VDD VNW pm1p2_svt_lp W=590e-9 L=60e-9 MR=1
MPM7 net36 ckb net33 VNW pm1p2_svt_lp W=590e-9 L=60e-9 MR=1
MPM6 net24 ckb net46 VNW pm1p2_svt_lp W=150e-9 L=60e-9 MR=1
MPM_RN net46 RN VDD VNW pm1p2_svt_lp W=150e-9 L=60e-9 MR=1
MPM5 net46 net33 VDD VNW pm1p2_svt_lp W=150e-9 L=60e-9 MR=1
MPM4 net33 net24 VDD VNW pm1p2_svt_lp W=350e-9 L=60e-9 MR=1
MPM_SE0 sen SE VDD VNW pm1p2_svt_lp W=300e-9 L=60e-9 MR=1
MPM3 net24 cknn net20 VNW pm1p2_svt_lp W=590e-9 L=60e-9 MR=1
MPMR2 net58 SI VDD VNW pm1p2_svt_lp W=590e-9 L=60e-9 MR=1
MPML2 net59 D VDD VNW pm1p2_svt_lp W=590e-9 L=60e-9 MR=1
MPM_SE2 net20 sen net58 VNW pm1p2_svt_lp W=590e-9 L=60e-9 MR=1
MPM_SE1 net20 SE net59 VNW pm1p2_svt_lp W=590e-9 L=60e-9 MR=1
MPM1 ckb cknn VDD VNW pm1p2_svt_lp W=300e-9 L=60e-9 MR=1
MPM0 cknn CKN VDD VNW pm1p2_svt_lp W=300e-9 L=60e-9 MR=1
.ENDS
.SUBCKT SDFFNRNQX2_9TSVT CKN D Q RN SE SI VDD VSS VNW VPW
MNM11 Q net39 VSS VPW nm1p2_svt_lp W=940e-9 L=60e-9 MR=1
MNM9 net51 net39 VSS VPW nm1p2_svt_lp W=150e-9 L=60e-9 MR=1
MNM10 net36 ckb net51 VPW nm1p2_svt_lp W=150e-9 L=60e-9 MR=1
MNM_RN2 net53 RN VSS VPW nm1p2_svt_lp W=470e-9 L=60e-9 MR=1
MNM8 net39 net36 net53 VPW nm1p2_svt_lp W=470e-9 L=60e-9 MR=1
MNM7 net36 cknn net33 VPW nm1p2_svt_lp W=470e-9 L=60e-9 MR=1
MNM_RN net54 RN VSS VPW nm1p2_svt_lp W=150e-9 L=60e-9 MR=1
MNM5 net55 net33 net54 VPW nm1p2_svt_lp W=150e-9 L=60e-9 MR=1
MNM6 net24 cknn net55 VPW nm1p2_svt_lp W=150e-9 L=60e-9 MR=1
MNM4 net33 net24 VSS VPW nm1p2_svt_lp W=470e-9 L=60e-9 MR=1
MNM_SE0 sen SE VSS VPW nm1p2_svt_lp W=230e-9 L=60e-9 MR=1
MNMR2 net56 SI VSS VPW nm1p2_svt_lp W=470e-9 L=60e-9 MR=1
MNML2 net57 D VSS VPW nm1p2_svt_lp W=470e-9 L=60e-9 MR=1
MNM_SE2 net20 SE net56 VPW nm1p2_svt_lp W=470e-9 L=60e-9 MR=1
MNM_SE1 net20 sen net57 VPW nm1p2_svt_lp W=470e-9 L=60e-9 MR=1
MNM3 net24 ckb net20 VPW nm1p2_svt_lp W=470e-9 L=60e-9 MR=1
MNM1 ckb cknn VSS VPW nm1p2_svt_lp W=230e-9 L=60e-9 MR=1
MNM0 cknn CKN VSS VPW nm1p2_svt_lp W=230e-9 L=60e-9 MR=1
MPM11 Q net39 VDD VNW pm1p2_svt_lp W=1.18e-6 L=60e-9 MR=1
MPM10 net36 cknn net52 VNW pm1p2_svt_lp W=150e-9 L=60e-9 MR=1
MPM9 net52 net39 VDD VNW pm1p2_svt_lp W=150e-9 L=60e-9 MR=1
MPM_RN2 net39 RN VDD VNW pm1p2_svt_lp W=590e-9 L=60e-9 MR=1
MPM8 net39 net36 VDD VNW pm1p2_svt_lp W=590e-9 L=60e-9 MR=1
MPM7 net36 ckb net33 VNW pm1p2_svt_lp W=590e-9 L=60e-9 MR=1
MPM6 net24 ckb net46 VNW pm1p2_svt_lp W=150e-9 L=60e-9 MR=1
MPM_RN net46 RN VDD VNW pm1p2_svt_lp W=150e-9 L=60e-9 MR=1
MPM5 net46 net33 VDD VNW pm1p2_svt_lp W=150e-9 L=60e-9 MR=1
MPM4 net33 net24 VDD VNW pm1p2_svt_lp W=350e-9 L=60e-9 MR=1
MPM_SE0 sen SE VDD VNW pm1p2_svt_lp W=300e-9 L=60e-9 MR=1
MPM3 net24 cknn net20 VNW pm1p2_svt_lp W=590e-9 L=60e-9 MR=1
MPMR2 net58 SI VDD VNW pm1p2_svt_lp W=590e-9 L=60e-9 MR=1
MPML2 net59 D VDD VNW pm1p2_svt_lp W=590e-9 L=60e-9 MR=1
MPM_SE2 net20 sen net58 VNW pm1p2_svt_lp W=590e-9 L=60e-9 MR=1
MPM_SE1 net20 SE net59 VNW pm1p2_svt_lp W=590e-9 L=60e-9 MR=1
MPM1 ckb cknn VDD VNW pm1p2_svt_lp W=300e-9 L=60e-9 MR=1
MPM0 cknn CKN VDD VNW pm1p2_svt_lp W=300e-9 L=60e-9 MR=1
.ENDS
.SUBCKT SDFFNRNQX4_9TSVT CKN D Q RN SE SI VDD VSS VNW VPW
MNM11 Q net39 VSS VPW nm1p2_svt_lp W=1.88e-6 L=60e-9 MR=1
MNM9 net51 net39 VSS VPW nm1p2_svt_lp W=150e-9 L=60e-9 MR=1
MNM10 net36 ckb net51 VPW nm1p2_svt_lp W=150e-9 L=60e-9 MR=1
MNM_RN2 net53 RN VSS VPW nm1p2_svt_lp W=940e-9 L=60e-9 MR=1
MNM8 net39 net36 net53 VPW nm1p2_svt_lp W=940e-9 L=60e-9 MR=1
MNM7 net36 cknn net33 VPW nm1p2_svt_lp W=470e-9 L=60e-9 MR=1
MNM_RN net54 RN VSS VPW nm1p2_svt_lp W=150e-9 L=60e-9 MR=1
MNM5 net55 net33 net54 VPW nm1p2_svt_lp W=150e-9 L=60e-9 MR=1
MNM6 net24 cknn net55 VPW nm1p2_svt_lp W=150e-9 L=60e-9 MR=1
MNM4 net33 net24 VSS VPW nm1p2_svt_lp W=470e-9 L=60e-9 MR=1
MNM_SE0 sen SE VSS VPW nm1p2_svt_lp W=230e-9 L=60e-9 MR=1
MNMR2 net56 SI VSS VPW nm1p2_svt_lp W=470e-9 L=60e-9 MR=1
MNML2 net57 D VSS VPW nm1p2_svt_lp W=470e-9 L=60e-9 MR=1
MNM_SE2 net20 SE net56 VPW nm1p2_svt_lp W=470e-9 L=60e-9 MR=1
MNM_SE1 net20 sen net57 VPW nm1p2_svt_lp W=470e-9 L=60e-9 MR=1
MNM3 net24 ckb net20 VPW nm1p2_svt_lp W=470e-9 L=60e-9 MR=1
MNM1 ckb cknn VSS VPW nm1p2_svt_lp W=470e-9 L=60e-9 MR=1
MNM0 cknn CKN VSS VPW nm1p2_svt_lp W=470e-9 L=60e-9 MR=1
MPM11 Q net39 VDD VNW pm1p2_svt_lp W=2.36e-6 L=60e-9 MR=1
MPM10 net36 cknn net52 VNW pm1p2_svt_lp W=150e-9 L=60e-9 MR=1
MPM9 net52 net39 VDD VNW pm1p2_svt_lp W=150e-9 L=60e-9 MR=1
MPM_RN2 net39 RN VDD VNW pm1p2_svt_lp W=1.18e-6 L=60e-9 MR=1
MPM8 net39 net36 VDD VNW pm1p2_svt_lp W=1.18e-6 L=60e-9 MR=1
MPM7 net36 ckb net33 VNW pm1p2_svt_lp W=590e-9 L=60e-9 MR=1
MPM6 net24 ckb net46 VNW pm1p2_svt_lp W=150e-9 L=60e-9 MR=1
MPM_RN net46 RN VDD VNW pm1p2_svt_lp W=150e-9 L=60e-9 MR=1
MPM5 net46 net33 VDD VNW pm1p2_svt_lp W=150e-9 L=60e-9 MR=1
MPM4 net33 net24 VDD VNW pm1p2_svt_lp W=350e-9 L=60e-9 MR=1
MPM_SE0 sen SE VDD VNW pm1p2_svt_lp W=300e-9 L=60e-9 MR=1
MPM3 net24 cknn net20 VNW pm1p2_svt_lp W=590e-9 L=60e-9 MR=1
MPMR2 net58 SI VDD VNW pm1p2_svt_lp W=590e-9 L=60e-9 MR=1
MPML2 net59 D VDD VNW pm1p2_svt_lp W=590e-9 L=60e-9 MR=1
MPM_SE2 net20 sen net58 VNW pm1p2_svt_lp W=590e-9 L=60e-9 MR=1
MPM_SE1 net20 SE net59 VNW pm1p2_svt_lp W=590e-9 L=60e-9 MR=1
MPM1 ckb cknn VDD VNW pm1p2_svt_lp W=590e-9 L=60e-9 MR=1
MPM0 cknn CKN VDD VNW pm1p2_svt_lp W=590e-9 L=60e-9 MR=1
.ENDS
.SUBCKT SDFFNRSNQX0P5_9TSVT CKN D Q RN SE SI SN VDD VSS VNW VPW
MNM11 Q net40 VSS VPW nm1p2_svt_lp W=230e-9 L=60e-9 MR=1
MNM9 net56 net40 VSS VPW nm1p2_svt_lp W=150e-9 L=60e-9 MR=1
MNM_SN2 net57 SN net56 VPW nm1p2_svt_lp W=150e-9 L=60e-9 MR=1
MNM10 net37 ckb net57 VPW nm1p2_svt_lp W=150e-9 L=60e-9 MR=1
MNM_RN2 net58 RN VSS VPW nm1p2_svt_lp W=230e-9 L=60e-9 MR=1
MNM8 net40 net37 net58 VPW nm1p2_svt_lp W=230e-9 L=60e-9 MR=1
MNM7 net37 cknn net32 VPW nm1p2_svt_lp W=230e-9 L=60e-9 MR=1
MNM_RN net59 RN VSS VPW nm1p2_svt_lp W=150e-9 L=60e-9 MR=1
MNM5 net60 net32 net59 VPW nm1p2_svt_lp W=150e-9 L=60e-9 MR=1
MNM6 net26 cknn net60 VPW nm1p2_svt_lp W=150e-9 L=60e-9 MR=1
MNM4 net61 net26 VSS VPW nm1p2_svt_lp W=230e-9 L=60e-9 MR=1
MNM_SN net32 SN net61 VPW nm1p2_svt_lp W=230e-9 L=60e-9 MR=1
MNM_SE0 sen SE VSS VPW nm1p2_svt_lp W=230e-9 L=60e-9 MR=1
MNMR2 net62 SI VSS VPW nm1p2_svt_lp W=230e-9 L=60e-9 MR=1
MNML2 net63 D VSS VPW nm1p2_svt_lp W=230e-9 L=60e-9 MR=1
MNM_SE2 net22 SE net62 VPW nm1p2_svt_lp W=230e-9 L=60e-9 MR=1
MNM_SE1 net22 sen net63 VPW nm1p2_svt_lp W=230e-9 L=60e-9 MR=1
MNM3 net26 ckb net22 VPW nm1p2_svt_lp W=230e-9 L=60e-9 MR=1
MNM1 ckb cknn VSS VPW nm1p2_svt_lp W=230e-9 L=60e-9 MR=1
MNM0 cknn CKN VSS VPW nm1p2_svt_lp W=230e-9 L=60e-9 MR=1
MPM11 Q net40 VDD VNW pm1p2_svt_lp W=300e-9 L=60e-9 MR=1
MPM10 net37 cknn net54 VNW pm1p2_svt_lp W=150e-9 L=60e-9 MR=1
MPM_SN2 net54 SN VDD VNW pm1p2_svt_lp W=150e-9 L=60e-9 MR=1
MPM9 net54 net40 VDD VNW pm1p2_svt_lp W=150e-9 L=60e-9 MR=1
MPM_RN2 net40 RN VDD VNW pm1p2_svt_lp W=300e-9 L=60e-9 MR=1
MPM8 net40 net37 VDD VNW pm1p2_svt_lp W=300e-9 L=60e-9 MR=1
MPM7 net37 ckb net32 VNW pm1p2_svt_lp W=300e-9 L=60e-9 MR=1
MPM6 net26 ckb net49 VNW pm1p2_svt_lp W=150e-9 L=60e-9 MR=1
MPM_RN net49 RN VDD VNW pm1p2_svt_lp W=150e-9 L=60e-9 MR=1
MPM5 net49 net32 VDD VNW pm1p2_svt_lp W=150e-9 L=60e-9 MR=1
MPM_SN net32 SN VDD VNW pm1p2_svt_lp W=300e-9 L=60e-9 MR=1
MPM4 net32 net26 VDD VNW pm1p2_svt_lp W=300e-9 L=60e-9 MR=1
MPM_SE0 sen SE VDD VNW pm1p2_svt_lp W=300e-9 L=60e-9 MR=1
MPM3 net26 cknn net22 VNW pm1p2_svt_lp W=300e-9 L=60e-9 MR=1
MPMR2 net64 SI VDD VNW pm1p2_svt_lp W=300e-9 L=60e-9 MR=1
MPML2 net65 D VDD VNW pm1p2_svt_lp W=300e-9 L=60e-9 MR=1
MPM_SE2 net22 sen net64 VNW pm1p2_svt_lp W=300e-9 L=60e-9 MR=1
MPM_SE1 net22 SE net65 VNW pm1p2_svt_lp W=300e-9 L=60e-9 MR=1
MPM1 ckb cknn VDD VNW pm1p2_svt_lp W=300e-9 L=60e-9 MR=1
MPM0 cknn CKN VDD VNW pm1p2_svt_lp W=300e-9 L=60e-9 MR=1
.ENDS
.SUBCKT SDFFNRSNQX1_9TSVT CKN D Q RN SE SI SN VDD VSS VNW VPW
MNM11 Q net40 VSS VPW nm1p2_svt_lp W=470e-9 L=60e-9 MR=1
MNM9 net56 net40 VSS VPW nm1p2_svt_lp W=150e-9 L=60e-9 MR=1
MNM_SN2 net57 SN net56 VPW nm1p2_svt_lp W=150e-9 L=60e-9 MR=1
MNM10 net37 ckb net57 VPW nm1p2_svt_lp W=150e-9 L=60e-9 MR=1
MNM_RN2 net58 RN VSS VPW nm1p2_svt_lp W=470e-9 L=60e-9 MR=1
MNM8 net40 net37 net58 VPW nm1p2_svt_lp W=470e-9 L=60e-9 MR=1
MNM7 net37 cknn net32 VPW nm1p2_svt_lp W=290e-9 L=60e-9 MR=1
MNM_RN net59 RN VSS VPW nm1p2_svt_lp W=150e-9 L=60e-9 MR=1
MNM5 net60 net32 net59 VPW nm1p2_svt_lp W=150e-9 L=60e-9 MR=1
MNM6 net26 cknn net60 VPW nm1p2_svt_lp W=150e-9 L=60e-9 MR=1
MNM4 net61 net26 VSS VPW nm1p2_svt_lp W=470e-9 L=60e-9 MR=1
MNM_SN net32 SN net61 VPW nm1p2_svt_lp W=470e-9 L=60e-9 MR=1
MNM_SE0 sen SE VSS VPW nm1p2_svt_lp W=230e-9 L=60e-9 MR=1
MNMR2 net62 SI VSS VPW nm1p2_svt_lp W=470e-9 L=60e-9 MR=1
MNML2 net63 D VSS VPW nm1p2_svt_lp W=470e-9 L=60e-9 MR=1
MNM_SE2 net22 SE net62 VPW nm1p2_svt_lp W=470e-9 L=60e-9 MR=1
MNM_SE1 net22 sen net63 VPW nm1p2_svt_lp W=470e-9 L=60e-9 MR=1
MNM3 net26 ckb net22 VPW nm1p2_svt_lp W=470e-9 L=60e-9 MR=1
MNM1 ckb cknn VSS VPW nm1p2_svt_lp W=230e-9 L=60e-9 MR=1
MNM0 cknn CKN VSS VPW nm1p2_svt_lp W=230e-9 L=60e-9 MR=1
MPM11 Q net40 VDD VNW pm1p2_svt_lp W=590e-9 L=60e-9 MR=1
MPM10 net37 cknn net54 VNW pm1p2_svt_lp W=150e-9 L=60e-9 MR=1
MPM_SN2 net54 SN VDD VNW pm1p2_svt_lp W=150e-9 L=60e-9 MR=1
MPM9 net54 net40 VDD VNW pm1p2_svt_lp W=150e-9 L=60e-9 MR=1
MPM_RN2 net40 RN VDD VNW pm1p2_svt_lp W=590e-9 L=60e-9 MR=1
MPM8 net40 net37 VDD VNW pm1p2_svt_lp W=590e-9 L=60e-9 MR=1
MPM7 net37 ckb net32 VNW pm1p2_svt_lp W=590e-9 L=60e-9 MR=1
MPM6 net26 ckb net49 VNW pm1p2_svt_lp W=150e-9 L=60e-9 MR=1
MPM_RN net49 RN VDD VNW pm1p2_svt_lp W=150e-9 L=60e-9 MR=1
MPM5 net49 net32 VDD VNW pm1p2_svt_lp W=150e-9 L=60e-9 MR=1
MPM_SN net32 SN VDD VNW pm1p2_svt_lp W=370e-9 L=60e-9 MR=1
MPM4 net32 net26 VDD VNW pm1p2_svt_lp W=390e-9 L=60e-9 MR=1
MPM_SE0 sen SE VDD VNW pm1p2_svt_lp W=300e-9 L=60e-9 MR=1
MPM3 net26 cknn net22 VNW pm1p2_svt_lp W=590e-9 L=60e-9 MR=1
MPMR2 net64 SI VDD VNW pm1p2_svt_lp W=590e-9 L=60e-9 MR=1
MPML2 net65 D VDD VNW pm1p2_svt_lp W=590e-9 L=60e-9 MR=1
MPM_SE2 net22 sen net64 VNW pm1p2_svt_lp W=590e-9 L=60e-9 MR=1
MPM_SE1 net22 SE net65 VNW pm1p2_svt_lp W=590e-9 L=60e-9 MR=1
MPM1 ckb cknn VDD VNW pm1p2_svt_lp W=300e-9 L=60e-9 MR=1
MPM0 cknn CKN VDD VNW pm1p2_svt_lp W=300e-9 L=60e-9 MR=1
.ENDS
.SUBCKT SDFFNRSNQX2_9TSVT CKN D Q RN SE SI SN VDD VSS VNW VPW
MNM11 Q net40 VSS VPW nm1p2_svt_lp W=940e-9 L=60e-9 MR=1
MNM9 net56 net40 VSS VPW nm1p2_svt_lp W=150e-9 L=60e-9 MR=1
MNM_SN2 net57 SN net56 VPW nm1p2_svt_lp W=150e-9 L=60e-9 MR=1
MNM10 net37 ckb net57 VPW nm1p2_svt_lp W=150e-9 L=60e-9 MR=1
MNM_RN2 net58 RN VSS VPW nm1p2_svt_lp W=470e-9 L=60e-9 MR=1
MNM8 net40 net37 net58 VPW nm1p2_svt_lp W=470e-9 L=60e-9 MR=1
MNM7 net37 cknn net32 VPW nm1p2_svt_lp W=290e-9 L=60e-9 MR=1
MNM_RN net59 RN VSS VPW nm1p2_svt_lp W=150e-9 L=60e-9 MR=1
MNM5 net60 net32 net59 VPW nm1p2_svt_lp W=150e-9 L=60e-9 MR=1
MNM6 net26 cknn net60 VPW nm1p2_svt_lp W=150e-9 L=60e-9 MR=1
MNM4 net61 net26 VSS VPW nm1p2_svt_lp W=470e-9 L=60e-9 MR=1
MNM_SN net32 SN net61 VPW nm1p2_svt_lp W=470e-9 L=60e-9 MR=1
MNM_SE0 sen SE VSS VPW nm1p2_svt_lp W=230e-9 L=60e-9 MR=1
MNMR2 net62 SI VSS VPW nm1p2_svt_lp W=470e-9 L=60e-9 MR=1
MNML2 net63 D VSS VPW nm1p2_svt_lp W=470e-9 L=60e-9 MR=1
MNM_SE2 net22 SE net62 VPW nm1p2_svt_lp W=470e-9 L=60e-9 MR=1
MNM_SE1 net22 sen net63 VPW nm1p2_svt_lp W=470e-9 L=60e-9 MR=1
MNM3 net26 ckb net22 VPW nm1p2_svt_lp W=470e-9 L=60e-9 MR=1
MNM1 ckb cknn VSS VPW nm1p2_svt_lp W=230e-9 L=60e-9 MR=1
MNM0 cknn CKN VSS VPW nm1p2_svt_lp W=230e-9 L=60e-9 MR=1
MPM11 Q net40 VDD VNW pm1p2_svt_lp W=1.18e-6 L=60e-9 MR=1
MPM10 net37 cknn net54 VNW pm1p2_svt_lp W=150e-9 L=60e-9 MR=1
MPM_SN2 net54 SN VDD VNW pm1p2_svt_lp W=150e-9 L=60e-9 MR=1
MPM9 net54 net40 VDD VNW pm1p2_svt_lp W=150e-9 L=60e-9 MR=1
MPM_RN2 net40 RN VDD VNW pm1p2_svt_lp W=590e-9 L=60e-9 MR=1
MPM8 net40 net37 VDD VNW pm1p2_svt_lp W=590e-9 L=60e-9 MR=1
MPM7 net37 ckb net32 VNW pm1p2_svt_lp W=590e-9 L=60e-9 MR=1
MPM6 net26 ckb net49 VNW pm1p2_svt_lp W=150e-9 L=60e-9 MR=1
MPM_RN net49 RN VDD VNW pm1p2_svt_lp W=150e-9 L=60e-9 MR=1
MPM5 net49 net32 VDD VNW pm1p2_svt_lp W=150e-9 L=60e-9 MR=1
MPM_SN net32 SN VDD VNW pm1p2_svt_lp W=370e-9 L=60e-9 MR=1
MPM4 net32 net26 VDD VNW pm1p2_svt_lp W=390e-9 L=60e-9 MR=1
MPM_SE0 sen SE VDD VNW pm1p2_svt_lp W=300e-9 L=60e-9 MR=1
MPM3 net26 cknn net22 VNW pm1p2_svt_lp W=590e-9 L=60e-9 MR=1
MPMR2 net64 SI VDD VNW pm1p2_svt_lp W=590e-9 L=60e-9 MR=1
MPML2 net65 D VDD VNW pm1p2_svt_lp W=590e-9 L=60e-9 MR=1
MPM_SE2 net22 sen net64 VNW pm1p2_svt_lp W=590e-9 L=60e-9 MR=1
MPM_SE1 net22 SE net65 VNW pm1p2_svt_lp W=590e-9 L=60e-9 MR=1
MPM1 ckb cknn VDD VNW pm1p2_svt_lp W=300e-9 L=60e-9 MR=1
MPM0 cknn CKN VDD VNW pm1p2_svt_lp W=300e-9 L=60e-9 MR=1
.ENDS
.SUBCKT SDFFNRSNQX4_9TSVT CKN D Q RN SE SI SN VDD VSS VNW VPW
MNM11 Q net40 VSS VPW nm1p2_svt_lp W=1.88e-6 L=60e-9 MR=1
MNM9 net56 net40 VSS VPW nm1p2_svt_lp W=150e-9 L=60e-9 MR=1
MNM_SN2 net57 SN net56 VPW nm1p2_svt_lp W=150e-9 L=60e-9 MR=1
MNM10 net37 ckb net57 VPW nm1p2_svt_lp W=150e-9 L=60e-9 MR=1
MNM_RN2 net58 RN VSS VPW nm1p2_svt_lp W=940e-9 L=60e-9 MR=1
MNM8 net40 net37 net58 VPW nm1p2_svt_lp W=940e-9 L=60e-9 MR=1
MNM7 net37 cknn net32 VPW nm1p2_svt_lp W=290e-9 L=60e-9 MR=1
MNM_RN net59 RN VSS VPW nm1p2_svt_lp W=150e-9 L=60e-9 MR=1
MNM5 net60 net32 net59 VPW nm1p2_svt_lp W=150e-9 L=60e-9 MR=1
MNM6 net26 cknn net60 VPW nm1p2_svt_lp W=150e-9 L=60e-9 MR=1
MNM4 net61 net26 VSS VPW nm1p2_svt_lp W=470e-9 L=60e-9 MR=1
MNM_SN net32 SN net61 VPW nm1p2_svt_lp W=470e-9 L=60e-9 MR=1
MNM_SE0 sen SE VSS VPW nm1p2_svt_lp W=230e-9 L=60e-9 MR=1
MNMR2 net62 SI VSS VPW nm1p2_svt_lp W=470e-9 L=60e-9 MR=1
MNML2 net63 D VSS VPW nm1p2_svt_lp W=470e-9 L=60e-9 MR=1
MNM_SE2 net22 SE net62 VPW nm1p2_svt_lp W=470e-9 L=60e-9 MR=1
MNM_SE1 net22 sen net63 VPW nm1p2_svt_lp W=470e-9 L=60e-9 MR=1
MNM3 net26 ckb net22 VPW nm1p2_svt_lp W=470e-9 L=60e-9 MR=1
MNM1 ckb cknn VSS VPW nm1p2_svt_lp W=270e-9 L=60e-9 MR=1
MNM0 cknn CKN VSS VPW nm1p2_svt_lp W=470e-9 L=60e-9 MR=1
MPM11 Q net40 VDD VNW pm1p2_svt_lp W=2.36e-6 L=60e-9 MR=1
MPM10 net37 cknn net54 VNW pm1p2_svt_lp W=150e-9 L=60e-9 MR=1
MPM_SN2 net54 SN VDD VNW pm1p2_svt_lp W=150e-9 L=60e-9 MR=1
MPM9 net54 net40 VDD VNW pm1p2_svt_lp W=150e-9 L=60e-9 MR=1
MPM_RN2 net40 RN VDD VNW pm1p2_svt_lp W=1.18e-6 L=60e-9 MR=1
MPM8 net40 net37 VDD VNW pm1p2_svt_lp W=1.18e-6 L=60e-9 MR=1
MPM7 net37 ckb net32 VNW pm1p2_svt_lp W=590e-9 L=60e-9 MR=1
MPM6 net26 ckb net49 VNW pm1p2_svt_lp W=150e-9 L=60e-9 MR=1
MPM_RN net49 RN VDD VNW pm1p2_svt_lp W=150e-9 L=60e-9 MR=1
MPM5 net49 net32 VDD VNW pm1p2_svt_lp W=150e-9 L=60e-9 MR=1
MPM_SN net32 SN VDD VNW pm1p2_svt_lp W=370e-9 L=60e-9 MR=1
MPM4 net32 net26 VDD VNW pm1p2_svt_lp W=390e-9 L=60e-9 MR=1
MPM_SE0 sen SE VDD VNW pm1p2_svt_lp W=300e-9 L=60e-9 MR=1
MPM3 net26 cknn net22 VNW pm1p2_svt_lp W=590e-9 L=60e-9 MR=1
MPMR2 net64 SI VDD VNW pm1p2_svt_lp W=590e-9 L=60e-9 MR=1
MPML2 net65 D VDD VNW pm1p2_svt_lp W=590e-9 L=60e-9 MR=1
MPM_SE2 net22 sen net64 VNW pm1p2_svt_lp W=590e-9 L=60e-9 MR=1
MPM_SE1 net22 SE net65 VNW pm1p2_svt_lp W=590e-9 L=60e-9 MR=1
MPM1 ckb cknn VDD VNW pm1p2_svt_lp W=590e-9 L=60e-9 MR=1
MPM0 cknn CKN VDD VNW pm1p2_svt_lp W=590e-9 L=60e-9 MR=1
.ENDS
.SUBCKT SDFFNSNQX0P5_9TSVT CKN D Q SE SI SN VDD VSS VNW VPW
MNM11 Q net41 VSS VPW nm1p2_svt_lp W=230e-9 L=60e-9 MR=1
MNM9 net51 net41 VSS VPW nm1p2_svt_lp W=150e-9 L=60e-9 MR=1
MNM_SN2 net52 SN net51 VPW nm1p2_svt_lp W=150e-9 L=60e-9 MR=1
MNM10 net35 ckb net52 VPW nm1p2_svt_lp W=150e-9 L=60e-9 MR=1
MNM8 net41 net35 VSS VPW nm1p2_svt_lp W=230e-9 L=60e-9 MR=1
MNM7 net35 cknn net30 VPW nm1p2_svt_lp W=230e-9 L=60e-9 MR=1
MNM5 net53 net30 VSS VPW nm1p2_svt_lp W=150e-9 L=60e-9 MR=1
MNM6 net24 cknn net53 VPW nm1p2_svt_lp W=150e-9 L=60e-9 MR=1
MNM4 net55 net24 VSS VPW nm1p2_svt_lp W=230e-9 L=60e-9 MR=1
MNM_SN net30 SN net55 VPW nm1p2_svt_lp W=230e-9 L=60e-9 MR=1
MNM_SE0 sen SE VSS VPW nm1p2_svt_lp W=230e-9 L=60e-9 MR=1
MNMR2 net56 SI VSS VPW nm1p2_svt_lp W=230e-9 L=60e-9 MR=1
MNML2 net57 D VSS VPW nm1p2_svt_lp W=230e-9 L=60e-9 MR=1
MNM_SE2 net20 SE net56 VPW nm1p2_svt_lp W=230e-9 L=60e-9 MR=1
MNM_SE1 net20 sen net57 VPW nm1p2_svt_lp W=230e-9 L=60e-9 MR=1
MNM3 net24 ckb net20 VPW nm1p2_svt_lp W=230e-9 L=60e-9 MR=1
MNM1 ckb cknn VSS VPW nm1p2_svt_lp W=230e-9 L=60e-9 MR=1
MNM0 cknn CKN VSS VPW nm1p2_svt_lp W=230e-9 L=60e-9 MR=1
MPM11 Q net41 VDD VNW pm1p2_svt_lp W=300e-9 L=60e-9 MR=1
MPM10 net35 cknn net49 VNW pm1p2_svt_lp W=150e-9 L=60e-9 MR=1
MPM_SN2 net49 SN VDD VNW pm1p2_svt_lp W=150e-9 L=60e-9 MR=1
MPM9 net49 net41 VDD VNW pm1p2_svt_lp W=150e-9 L=60e-9 MR=1
MPM8 net41 net35 VDD VNW pm1p2_svt_lp W=300e-9 L=60e-9 MR=1
MPM7 net35 ckb net30 VNW pm1p2_svt_lp W=300e-9 L=60e-9 MR=1
MPM6 net24 ckb net54 VNW pm1p2_svt_lp W=150e-9 L=60e-9 MR=1
MPM5 net54 net30 VDD VNW pm1p2_svt_lp W=150e-9 L=60e-9 MR=1
MPM_SN net30 SN VDD VNW pm1p2_svt_lp W=300e-9 L=60e-9 MR=1
MPM4 net30 net24 VDD VNW pm1p2_svt_lp W=300e-9 L=60e-9 MR=1
MPM_SE0 sen SE VDD VNW pm1p2_svt_lp W=300e-9 L=60e-9 MR=1
MPM3 net24 cknn net20 VNW pm1p2_svt_lp W=300e-9 L=60e-9 MR=1
MPMR2 net58 SI VDD VNW pm1p2_svt_lp W=300e-9 L=60e-9 MR=1
MPML2 net59 D VDD VNW pm1p2_svt_lp W=300e-9 L=60e-9 MR=1
MPM_SE2 net20 sen net58 VNW pm1p2_svt_lp W=300e-9 L=60e-9 MR=1
MPM_SE1 net20 SE net59 VNW pm1p2_svt_lp W=300e-9 L=60e-9 MR=1
MPM1 ckb cknn VDD VNW pm1p2_svt_lp W=300e-9 L=60e-9 MR=1
MPM0 cknn CKN VDD VNW pm1p2_svt_lp W=300e-9 L=60e-9 MR=1
.ENDS
.SUBCKT SDFFNSNQX1_9TSVT CKN D Q SE SI SN VDD VSS VNW VPW
MNM11 Q net41 VSS VPW nm1p2_svt_lp W=470e-9 L=60e-9 MR=1
MNM9 net51 net41 VSS VPW nm1p2_svt_lp W=150e-9 L=60e-9 MR=1
MNM_SN2 net52 SN net51 VPW nm1p2_svt_lp W=150e-9 L=60e-9 MR=1
MNM10 net35 ckb net52 VPW nm1p2_svt_lp W=150e-9 L=60e-9 MR=1
MNM8 net41 net35 VSS VPW nm1p2_svt_lp W=470e-9 L=60e-9 MR=1
MNM7 net35 cknn net30 VPW nm1p2_svt_lp W=290e-9 L=60e-9 MR=1
MNM5 net53 net30 VSS VPW nm1p2_svt_lp W=150e-9 L=60e-9 MR=1
MNM6 net24 cknn net53 VPW nm1p2_svt_lp W=150e-9 L=60e-9 MR=1
MNM4 net55 net24 VSS VPW nm1p2_svt_lp W=470e-9 L=60e-9 MR=1
MNM_SN net30 SN net55 VPW nm1p2_svt_lp W=470e-9 L=60e-9 MR=1
MNM_SE0 sen SE VSS VPW nm1p2_svt_lp W=230e-9 L=60e-9 MR=1
MNMR2 net56 SI VSS VPW nm1p2_svt_lp W=470e-9 L=60e-9 MR=1
MNML2 net57 D VSS VPW nm1p2_svt_lp W=470e-9 L=60e-9 MR=1
MNM_SE2 net20 SE net56 VPW nm1p2_svt_lp W=470e-9 L=60e-9 MR=1
MNM_SE1 net20 sen net57 VPW nm1p2_svt_lp W=470e-9 L=60e-9 MR=1
MNM3 net24 ckb net20 VPW nm1p2_svt_lp W=470e-9 L=60e-9 MR=1
MNM1 ckb cknn VSS VPW nm1p2_svt_lp W=230e-9 L=60e-9 MR=1
MNM0 cknn CKN VSS VPW nm1p2_svt_lp W=230e-9 L=60e-9 MR=1
MPM11 Q net41 VDD VNW pm1p2_svt_lp W=590e-9 L=60e-9 MR=1
MPM10 net35 cknn net49 VNW pm1p2_svt_lp W=150e-9 L=60e-9 MR=1
MPM_SN2 net49 SN VDD VNW pm1p2_svt_lp W=150e-9 L=60e-9 MR=1
MPM9 net49 net41 VDD VNW pm1p2_svt_lp W=150e-9 L=60e-9 MR=1
MPM8 net41 net35 VDD VNW pm1p2_svt_lp W=590e-9 L=60e-9 MR=1
MPM7 net35 ckb net30 VNW pm1p2_svt_lp W=590e-9 L=60e-9 MR=1
MPM6 net24 ckb net54 VNW pm1p2_svt_lp W=150e-9 L=60e-9 MR=1
MPM5 net54 net30 VDD VNW pm1p2_svt_lp W=150e-9 L=60e-9 MR=1
MPM_SN net30 SN VDD VNW pm1p2_svt_lp W=590e-9 L=60e-9 MR=1
MPM4 net30 net24 VDD VNW pm1p2_svt_lp W=590e-9 L=60e-9 MR=1
MPM_SE0 sen SE VDD VNW pm1p2_svt_lp W=300e-9 L=60e-9 MR=1
MPM3 net24 cknn net20 VNW pm1p2_svt_lp W=590e-9 L=60e-9 MR=1
MPMR2 net58 SI VDD VNW pm1p2_svt_lp W=590e-9 L=60e-9 MR=1
MPML2 net59 D VDD VNW pm1p2_svt_lp W=590e-9 L=60e-9 MR=1
MPM_SE2 net20 sen net58 VNW pm1p2_svt_lp W=590e-9 L=60e-9 MR=1
MPM_SE1 net20 SE net59 VNW pm1p2_svt_lp W=590e-9 L=60e-9 MR=1
MPM1 ckb cknn VDD VNW pm1p2_svt_lp W=300e-9 L=60e-9 MR=1
MPM0 cknn CKN VDD VNW pm1p2_svt_lp W=300e-9 L=60e-9 MR=1
.ENDS
.SUBCKT SDFFNSNQX2_9TSVT CKN D Q SE SI SN VDD VSS VNW VPW
MNM11 Q net41 VSS VPW nm1p2_svt_lp W=940e-9 L=60e-9 MR=1
MNM9 net51 net41 VSS VPW nm1p2_svt_lp W=150e-9 L=60e-9 MR=1
MNM_SN2 net52 SN net51 VPW nm1p2_svt_lp W=150e-9 L=60e-9 MR=1
MNM10 net35 ckb net52 VPW nm1p2_svt_lp W=150e-9 L=60e-9 MR=1
MNM8 net41 net35 VSS VPW nm1p2_svt_lp W=470e-9 L=60e-9 MR=1
MNM7 net35 cknn net30 VPW nm1p2_svt_lp W=290e-9 L=60e-9 MR=1
MNM5 net53 net30 VSS VPW nm1p2_svt_lp W=150e-9 L=60e-9 MR=1
MNM6 net24 cknn net53 VPW nm1p2_svt_lp W=150e-9 L=60e-9 MR=1
MNM4 net55 net24 VSS VPW nm1p2_svt_lp W=470e-9 L=60e-9 MR=1
MNM_SN net30 SN net55 VPW nm1p2_svt_lp W=470e-9 L=60e-9 MR=1
MNM_SE0 sen SE VSS VPW nm1p2_svt_lp W=230e-9 L=60e-9 MR=1
MNMR2 net56 SI VSS VPW nm1p2_svt_lp W=470e-9 L=60e-9 MR=1
MNML2 net57 D VSS VPW nm1p2_svt_lp W=470e-9 L=60e-9 MR=1
MNM_SE2 net20 SE net56 VPW nm1p2_svt_lp W=470e-9 L=60e-9 MR=1
MNM_SE1 net20 sen net57 VPW nm1p2_svt_lp W=470e-9 L=60e-9 MR=1
MNM3 net24 ckb net20 VPW nm1p2_svt_lp W=470e-9 L=60e-9 MR=1
MNM1 ckb cknn VSS VPW nm1p2_svt_lp W=230e-9 L=60e-9 MR=1
MNM0 cknn CKN VSS VPW nm1p2_svt_lp W=230e-9 L=60e-9 MR=1
MPM11 Q net41 VDD VNW pm1p2_svt_lp W=1.18e-6 L=60e-9 MR=1
MPM10 net35 cknn net49 VNW pm1p2_svt_lp W=150e-9 L=60e-9 MR=1
MPM_SN2 net49 SN VDD VNW pm1p2_svt_lp W=150e-9 L=60e-9 MR=1
MPM9 net49 net41 VDD VNW pm1p2_svt_lp W=150e-9 L=60e-9 MR=1
MPM8 net41 net35 VDD VNW pm1p2_svt_lp W=590e-9 L=60e-9 MR=1
MPM7 net35 ckb net30 VNW pm1p2_svt_lp W=590e-9 L=60e-9 MR=1
MPM6 net24 ckb net54 VNW pm1p2_svt_lp W=150e-9 L=60e-9 MR=1
MPM5 net54 net30 VDD VNW pm1p2_svt_lp W=150e-9 L=60e-9 MR=1
MPM_SN net30 SN VDD VNW pm1p2_svt_lp W=590e-9 L=60e-9 MR=1
MPM4 net30 net24 VDD VNW pm1p2_svt_lp W=590e-9 L=60e-9 MR=1
MPM_SE0 sen SE VDD VNW pm1p2_svt_lp W=300e-9 L=60e-9 MR=1
MPM3 net24 cknn net20 VNW pm1p2_svt_lp W=590e-9 L=60e-9 MR=1
MPMR2 net58 SI VDD VNW pm1p2_svt_lp W=590e-9 L=60e-9 MR=1
MPML2 net59 D VDD VNW pm1p2_svt_lp W=590e-9 L=60e-9 MR=1
MPM_SE2 net20 sen net58 VNW pm1p2_svt_lp W=590e-9 L=60e-9 MR=1
MPM_SE1 net20 SE net59 VNW pm1p2_svt_lp W=590e-9 L=60e-9 MR=1
MPM1 ckb cknn VDD VNW pm1p2_svt_lp W=300e-9 L=60e-9 MR=1
MPM0 cknn CKN VDD VNW pm1p2_svt_lp W=300e-9 L=60e-9 MR=1
.ENDS
.SUBCKT SDFFNSNQX4_9TSVT CKN D Q SE SI SN VDD VSS VNW VPW
MNM11 Q net41 VSS VPW nm1p2_svt_lp W=1.88e-6 L=60e-9 MR=1
MNM9 net51 net41 VSS VPW nm1p2_svt_lp W=150e-9 L=60e-9 MR=1
MNM_SN2 net52 SN net51 VPW nm1p2_svt_lp W=150e-9 L=60e-9 MR=1
MNM10 net35 ckb net52 VPW nm1p2_svt_lp W=150e-9 L=60e-9 MR=1
MNM8 net41 net35 VSS VPW nm1p2_svt_lp W=940e-9 L=60e-9 MR=1
MNM7 net35 cknn net30 VPW nm1p2_svt_lp W=290e-9 L=60e-9 MR=1
MNM5 net53 net30 VSS VPW nm1p2_svt_lp W=150e-9 L=60e-9 MR=1
MNM6 net24 cknn net53 VPW nm1p2_svt_lp W=150e-9 L=60e-9 MR=1
MNM4 net55 net24 VSS VPW nm1p2_svt_lp W=470e-9 L=60e-9 MR=1
MNM_SN net30 SN net55 VPW nm1p2_svt_lp W=470e-9 L=60e-9 MR=1
MNM_SE0 sen SE VSS VPW nm1p2_svt_lp W=230e-9 L=60e-9 MR=1
MNMR2 net56 SI VSS VPW nm1p2_svt_lp W=470e-9 L=60e-9 MR=1
MNML2 net57 D VSS VPW nm1p2_svt_lp W=470e-9 L=60e-9 MR=1
MNM_SE2 net20 SE net56 VPW nm1p2_svt_lp W=470e-9 L=60e-9 MR=1
MNM_SE1 net20 sen net57 VPW nm1p2_svt_lp W=470e-9 L=60e-9 MR=1
MNM3 net24 ckb net20 VPW nm1p2_svt_lp W=470e-9 L=60e-9 MR=1
MNM1 ckb cknn VSS VPW nm1p2_svt_lp W=470e-9 L=60e-9 MR=1
MNM0 cknn CKN VSS VPW nm1p2_svt_lp W=470e-9 L=60e-9 MR=1
MPM11 Q net41 VDD VNW pm1p2_svt_lp W=2.36e-6 L=60e-9 MR=1
MPM10 net35 cknn net49 VNW pm1p2_svt_lp W=150e-9 L=60e-9 MR=1
MPM_SN2 net49 SN VDD VNW pm1p2_svt_lp W=150e-9 L=60e-9 MR=1
MPM9 net49 net41 VDD VNW pm1p2_svt_lp W=150e-9 L=60e-9 MR=1
MPM8 net41 net35 VDD VNW pm1p2_svt_lp W=1.18e-6 L=60e-9 MR=1
MPM7 net35 ckb net30 VNW pm1p2_svt_lp W=590e-9 L=60e-9 MR=1
MPM6 net24 ckb net54 VNW pm1p2_svt_lp W=150e-9 L=60e-9 MR=1
MPM5 net54 net30 VDD VNW pm1p2_svt_lp W=150e-9 L=60e-9 MR=1
MPM_SN net30 SN VDD VNW pm1p2_svt_lp W=590e-9 L=60e-9 MR=1
MPM4 net30 net24 VDD VNW pm1p2_svt_lp W=590e-9 L=60e-9 MR=1
MPM_SE0 sen SE VDD VNW pm1p2_svt_lp W=300e-9 L=60e-9 MR=1
MPM3 net24 cknn net20 VNW pm1p2_svt_lp W=590e-9 L=60e-9 MR=1
MPMR2 net58 SI VDD VNW pm1p2_svt_lp W=590e-9 L=60e-9 MR=1
MPML2 net59 D VDD VNW pm1p2_svt_lp W=590e-9 L=60e-9 MR=1
MPM_SE2 net20 sen net58 VNW pm1p2_svt_lp W=590e-9 L=60e-9 MR=1
MPM_SE1 net20 SE net59 VNW pm1p2_svt_lp W=590e-9 L=60e-9 MR=1
MPM1 ckb cknn VDD VNW pm1p2_svt_lp W=590e-9 L=60e-9 MR=1
MPM0 cknn CKN VDD VNW pm1p2_svt_lp W=590e-9 L=60e-9 MR=1
.ENDS
.SUBCKT SDFFQX0P5_9TSVT CK D Q SE SI VDD VSS VNW VPW
MNM11 Q net40 VSS VPW nm1p2_svt_lp W=230e-9 L=60e-9 MR=1
MNM9 net46 net40 VSS VPW nm1p2_svt_lp W=150e-9 L=60e-9 MR=1
MNM10 net34 ckn net46 VPW nm1p2_svt_lp W=150e-9 L=60e-9 MR=1
MNM8 net40 net34 VSS VPW nm1p2_svt_lp W=230e-9 L=60e-9 MR=1
MNM7 net34 ckb net31 VPW nm1p2_svt_lp W=230e-9 L=60e-9 MR=1
MNM5 net48 net31 VSS VPW nm1p2_svt_lp W=150e-9 L=60e-9 MR=1
MNM6 net22 ckb net48 VPW nm1p2_svt_lp W=150e-9 L=60e-9 MR=1
MNM4 net31 net22 VSS VPW nm1p2_svt_lp W=230e-9 L=60e-9 MR=1
MNM_SE0 sen SE VSS VPW nm1p2_svt_lp W=230e-9 L=60e-9 MR=1
MNMR2 net50 SI VSS VPW nm1p2_svt_lp W=230e-9 L=60e-9 MR=1
MNML2 net51 D VSS VPW nm1p2_svt_lp W=230e-9 L=60e-9 MR=1
MNM_SE2 net18 SE net50 VPW nm1p2_svt_lp W=230e-9 L=60e-9 MR=1
MNM_SE1 net18 sen net51 VPW nm1p2_svt_lp W=230e-9 L=60e-9 MR=1
MNM3 net22 ckn net18 VPW nm1p2_svt_lp W=230e-9 L=60e-9 MR=1
MNM1 ckb ckn VSS VPW nm1p2_svt_lp W=230e-9 L=60e-9 MR=1
MNM0 ckn CK VSS VPW nm1p2_svt_lp W=230e-9 L=60e-9 MR=1
MPM11 Q net40 VDD VNW pm1p2_svt_lp W=300e-9 L=60e-9 MR=1
MPM10 net34 ckb net47 VNW pm1p2_svt_lp W=150e-9 L=60e-9 MR=1
MPM9 net47 net40 VDD VNW pm1p2_svt_lp W=150e-9 L=60e-9 MR=1
MPM8 net40 net34 VDD VNW pm1p2_svt_lp W=300e-9 L=60e-9 MR=1
MPM7 net34 ckn net31 VNW pm1p2_svt_lp W=300e-9 L=60e-9 MR=1
MPM6 net22 ckn net49 VNW pm1p2_svt_lp W=150e-9 L=60e-9 MR=1
MPM5 net49 net31 VDD VNW pm1p2_svt_lp W=150e-9 L=60e-9 MR=1
MPM4 net31 net22 VDD VNW pm1p2_svt_lp W=300e-9 L=60e-9 MR=1
MPM_SE0 sen SE VDD VNW pm1p2_svt_lp W=300e-9 L=60e-9 MR=1
MPM3 net22 ckb net18 VNW pm1p2_svt_lp W=300e-9 L=60e-9 MR=1
MPMR2 net52 SI VDD VNW pm1p2_svt_lp W=300e-9 L=60e-9 MR=1
MPML2 net53 D VDD VNW pm1p2_svt_lp W=300e-9 L=60e-9 MR=1
MPM_SE2 net18 sen net52 VNW pm1p2_svt_lp W=300e-9 L=60e-9 MR=1
MPM_SE1 net18 SE net53 VNW pm1p2_svt_lp W=300e-9 L=60e-9 MR=1
MPM1 ckb ckn VDD VNW pm1p2_svt_lp W=300e-9 L=60e-9 MR=1
MPM0 ckn CK VDD VNW pm1p2_svt_lp W=300e-9 L=60e-9 MR=1
.ENDS
.SUBCKT SDFFQX1_9TSVT CK D Q SE SI VDD VSS VNW VPW
MNM11 Q net40 VSS VPW nm1p2_svt_lp W=470e-9 L=60e-9 MR=1
MNM9 net46 net40 VSS VPW nm1p2_svt_lp W=150e-9 L=60e-9 MR=1
MNM10 net34 ckn net46 VPW nm1p2_svt_lp W=150e-9 L=60e-9 MR=1
MNM8 net40 net34 VSS VPW nm1p2_svt_lp W=470e-9 L=60e-9 MR=1
MNM7 net34 ckb net31 VPW nm1p2_svt_lp W=470e-9 L=60e-9 MR=1
MNM5 net48 net31 VSS VPW nm1p2_svt_lp W=150e-9 L=60e-9 MR=1
MNM6 net22 ckb net48 VPW nm1p2_svt_lp W=150e-9 L=60e-9 MR=1
MNM4 net31 net22 VSS VPW nm1p2_svt_lp W=470e-9 L=60e-9 MR=1
MNM_SE0 sen SE VSS VPW nm1p2_svt_lp W=230e-9 L=60e-9 MR=1
MNMR2 net50 SI VSS VPW nm1p2_svt_lp W=470e-9 L=60e-9 MR=1
MNML2 net51 D VSS VPW nm1p2_svt_lp W=470e-9 L=60e-9 MR=1
MNM_SE2 net18 SE net50 VPW nm1p2_svt_lp W=470e-9 L=60e-9 MR=1
MNM_SE1 net18 sen net51 VPW nm1p2_svt_lp W=470e-9 L=60e-9 MR=1
MNM3 net22 ckn net18 VPW nm1p2_svt_lp W=470e-9 L=60e-9 MR=1
MNM1 ckb ckn VSS VPW nm1p2_svt_lp W=230e-9 L=60e-9 MR=1
MNM0 ckn CK VSS VPW nm1p2_svt_lp W=230e-9 L=60e-9 MR=1
MPM11 Q net40 VDD VNW pm1p2_svt_lp W=590e-9 L=60e-9 MR=1
MPM10 net34 ckb net47 VNW pm1p2_svt_lp W=150e-9 L=60e-9 MR=1
MPM9 net47 net40 VDD VNW pm1p2_svt_lp W=150e-9 L=60e-9 MR=1
MPM8 net40 net34 VDD VNW pm1p2_svt_lp W=590e-9 L=60e-9 MR=1
MPM7 net34 ckn net31 VNW pm1p2_svt_lp W=590e-9 L=60e-9 MR=1
MPM6 net22 ckn net49 VNW pm1p2_svt_lp W=150e-9 L=60e-9 MR=1
MPM5 net49 net31 VDD VNW pm1p2_svt_lp W=150e-9 L=60e-9 MR=1
MPM4 net31 net22 VDD VNW pm1p2_svt_lp W=590e-9 L=60e-9 MR=1
MPM_SE0 sen SE VDD VNW pm1p2_svt_lp W=300e-9 L=60e-9 MR=1
MPM3 net22 ckb net18 VNW pm1p2_svt_lp W=590e-9 L=60e-9 MR=1
MPMR2 net52 SI VDD VNW pm1p2_svt_lp W=590e-9 L=60e-9 MR=1
MPML2 net53 D VDD VNW pm1p2_svt_lp W=590e-9 L=60e-9 MR=1
MPM_SE2 net18 sen net52 VNW pm1p2_svt_lp W=590e-9 L=60e-9 MR=1
MPM_SE1 net18 SE net53 VNW pm1p2_svt_lp W=590e-9 L=60e-9 MR=1
MPM1 ckb ckn VDD VNW pm1p2_svt_lp W=300e-9 L=60e-9 MR=1
MPM0 ckn CK VDD VNW pm1p2_svt_lp W=300e-9 L=60e-9 MR=1
.ENDS
.SUBCKT SDFFQX2_9TSVT CK D Q SE SI VDD VSS VNW VPW
MNM11 Q net40 VSS VPW nm1p2_svt_lp W=940e-9 L=60e-9 MR=1
MNM9 net46 net40 VSS VPW nm1p2_svt_lp W=150e-9 L=60e-9 MR=1
MNM10 net34 ckn net46 VPW nm1p2_svt_lp W=150e-9 L=60e-9 MR=1
MNM8 net40 net34 VSS VPW nm1p2_svt_lp W=470e-9 L=60e-9 MR=1
MNM7 net34 ckb net31 VPW nm1p2_svt_lp W=470e-9 L=60e-9 MR=1
MNM5 net48 net31 VSS VPW nm1p2_svt_lp W=150e-9 L=60e-9 MR=1
MNM6 net22 ckb net48 VPW nm1p2_svt_lp W=150e-9 L=60e-9 MR=1
MNM4 net31 net22 VSS VPW nm1p2_svt_lp W=470e-9 L=60e-9 MR=1
MNM_SE0 sen SE VSS VPW nm1p2_svt_lp W=230e-9 L=60e-9 MR=1
MNMR2 net50 SI VSS VPW nm1p2_svt_lp W=470e-9 L=60e-9 MR=1
MNML2 net51 D VSS VPW nm1p2_svt_lp W=470e-9 L=60e-9 MR=1
MNM_SE2 net18 SE net50 VPW nm1p2_svt_lp W=470e-9 L=60e-9 MR=1
MNM_SE1 net18 sen net51 VPW nm1p2_svt_lp W=470e-9 L=60e-9 MR=1
MNM3 net22 ckn net18 VPW nm1p2_svt_lp W=470e-9 L=60e-9 MR=1
MNM1 ckb ckn VSS VPW nm1p2_svt_lp W=230e-9 L=60e-9 MR=1
MNM0 ckn CK VSS VPW nm1p2_svt_lp W=230e-9 L=60e-9 MR=1
MPM11 Q net40 VDD VNW pm1p2_svt_lp W=1.18e-6 L=60e-9 MR=1
MPM10 net34 ckb net47 VNW pm1p2_svt_lp W=150e-9 L=60e-9 MR=1
MPM9 net47 net40 VDD VNW pm1p2_svt_lp W=150e-9 L=60e-9 MR=1
MPM8 net40 net34 VDD VNW pm1p2_svt_lp W=590e-9 L=60e-9 MR=1
MPM7 net34 ckn net31 VNW pm1p2_svt_lp W=590e-9 L=60e-9 MR=1
MPM6 net22 ckn net49 VNW pm1p2_svt_lp W=150e-9 L=60e-9 MR=1
MPM5 net49 net31 VDD VNW pm1p2_svt_lp W=150e-9 L=60e-9 MR=1
MPM4 net31 net22 VDD VNW pm1p2_svt_lp W=590e-9 L=60e-9 MR=1
MPM_SE0 sen SE VDD VNW pm1p2_svt_lp W=300e-9 L=60e-9 MR=1
MPM3 net22 ckb net18 VNW pm1p2_svt_lp W=590e-9 L=60e-9 MR=1
MPMR2 net52 SI VDD VNW pm1p2_svt_lp W=590e-9 L=60e-9 MR=1
MPML2 net53 D VDD VNW pm1p2_svt_lp W=590e-9 L=60e-9 MR=1
MPM_SE2 net18 sen net52 VNW pm1p2_svt_lp W=590e-9 L=60e-9 MR=1
MPM_SE1 net18 SE net53 VNW pm1p2_svt_lp W=590e-9 L=60e-9 MR=1
MPM1 ckb ckn VDD VNW pm1p2_svt_lp W=300e-9 L=60e-9 MR=1
MPM0 ckn CK VDD VNW pm1p2_svt_lp W=300e-9 L=60e-9 MR=1
.ENDS
.SUBCKT SDFFQX4_9TSVT CK D Q SE SI VDD VSS VNW VPW
MNM11 Q net40 VSS VPW nm1p2_svt_lp W=1.88e-6 L=60e-9 MR=1
MNM9 net46 net40 VSS VPW nm1p2_svt_lp W=150e-9 L=60e-9 MR=1
MNM10 net34 ckn net46 VPW nm1p2_svt_lp W=150e-9 L=60e-9 MR=1
MNM8 net40 net34 VSS VPW nm1p2_svt_lp W=940e-9 L=60e-9 MR=1
MNM7 net34 ckb net31 VPW nm1p2_svt_lp W=470e-9 L=60e-9 MR=1
MNM5 net48 net31 VSS VPW nm1p2_svt_lp W=150e-9 L=60e-9 MR=1
MNM6 net22 ckb net48 VPW nm1p2_svt_lp W=150e-9 L=60e-9 MR=1
MNM4 net31 net22 VSS VPW nm1p2_svt_lp W=470e-9 L=60e-9 MR=1
MNM_SE0 sen SE VSS VPW nm1p2_svt_lp W=230e-9 L=60e-9 MR=1
MNMR2 net50 SI VSS VPW nm1p2_svt_lp W=470e-9 L=60e-9 MR=1
MNML2 net51 D VSS VPW nm1p2_svt_lp W=470e-9 L=60e-9 MR=1
MNM_SE2 net18 SE net50 VPW nm1p2_svt_lp W=470e-9 L=60e-9 MR=1
MNM_SE1 net18 sen net51 VPW nm1p2_svt_lp W=470e-9 L=60e-9 MR=1
MNM3 net22 ckn net18 VPW nm1p2_svt_lp W=470e-9 L=60e-9 MR=1
MNM1 ckb ckn VSS VPW nm1p2_svt_lp W=470e-9 L=60e-9 MR=1
MNM0 ckn CK VSS VPW nm1p2_svt_lp W=470e-9 L=60e-9 MR=1
MPM11 Q net40 VDD VNW pm1p2_svt_lp W=2.36e-6 L=60e-9 MR=1
MPM10 net34 ckb net47 VNW pm1p2_svt_lp W=150e-9 L=60e-9 MR=1
MPM9 net47 net40 VDD VNW pm1p2_svt_lp W=150e-9 L=60e-9 MR=1
MPM8 net40 net34 VDD VNW pm1p2_svt_lp W=1.18e-6 L=60e-9 MR=1
MPM7 net34 ckn net31 VNW pm1p2_svt_lp W=590e-9 L=60e-9 MR=1
MPM6 net22 ckn net49 VNW pm1p2_svt_lp W=150e-9 L=60e-9 MR=1
MPM5 net49 net31 VDD VNW pm1p2_svt_lp W=150e-9 L=60e-9 MR=1
MPM4 net31 net22 VDD VNW pm1p2_svt_lp W=590e-9 L=60e-9 MR=1
MPM_SE0 sen SE VDD VNW pm1p2_svt_lp W=300e-9 L=60e-9 MR=1
MPM3 net22 ckb net18 VNW pm1p2_svt_lp W=590e-9 L=60e-9 MR=1
MPMR2 net52 SI VDD VNW pm1p2_svt_lp W=590e-9 L=60e-9 MR=1
MPML2 net53 D VDD VNW pm1p2_svt_lp W=590e-9 L=60e-9 MR=1
MPM_SE2 net18 sen net52 VNW pm1p2_svt_lp W=590e-9 L=60e-9 MR=1
MPM_SE1 net18 SE net53 VNW pm1p2_svt_lp W=590e-9 L=60e-9 MR=1
MPM1 ckb ckn VDD VNW pm1p2_svt_lp W=590e-9 L=60e-9 MR=1
MPM0 ckn CK VDD VNW pm1p2_svt_lp W=390e-9 L=60e-9 MR=1
.ENDS
.SUBCKT SDFFRNQX0P5_9TSVT CK D Q RN SE SI VDD VSS VNW VPW
MNM11 Q net39 VSS VPW nm1p2_svt_lp W=230e-9 L=60e-9 MR=1
MNM9 net51 net39 VSS VPW nm1p2_svt_lp W=150e-9 L=60e-9 MR=1
MNM10 net36 ckn net51 VPW nm1p2_svt_lp W=150e-9 L=60e-9 MR=1
MNM_RN2 net53 RN VSS VPW nm1p2_svt_lp W=230e-9 L=60e-9 MR=1
MNM8 net39 net36 net53 VPW nm1p2_svt_lp W=230e-9 L=60e-9 MR=1
MNM7 net36 ckb net33 VPW nm1p2_svt_lp W=230e-9 L=60e-9 MR=1
MNM_RN net54 RN VSS VPW nm1p2_svt_lp W=150e-9 L=60e-9 MR=1
MNM5 net55 net33 net54 VPW nm1p2_svt_lp W=150e-9 L=60e-9 MR=1
MNM6 net24 ckb net55 VPW nm1p2_svt_lp W=150e-9 L=60e-9 MR=1
MNM4 net33 net24 VSS VPW nm1p2_svt_lp W=230e-9 L=60e-9 MR=1
MNM_SE0 sen SE VSS VPW nm1p2_svt_lp W=230e-9 L=60e-9 MR=1
MNMR2 net56 SI VSS VPW nm1p2_svt_lp W=230e-9 L=60e-9 MR=1
MNML2 net57 D VSS VPW nm1p2_svt_lp W=230e-9 L=60e-9 MR=1
MNM_SE2 net20 SE net56 VPW nm1p2_svt_lp W=230e-9 L=60e-9 MR=1
MNM_SE1 net20 sen net57 VPW nm1p2_svt_lp W=230e-9 L=60e-9 MR=1
MNM3 net24 ckn net20 VPW nm1p2_svt_lp W=230e-9 L=60e-9 MR=1
MNM1 ckb ckn VSS VPW nm1p2_svt_lp W=230e-9 L=60e-9 MR=1
MNM0 ckn CK VSS VPW nm1p2_svt_lp W=230e-9 L=60e-9 MR=1
MPM11 Q net39 VDD VNW pm1p2_svt_lp W=300e-9 L=60e-9 MR=1
MPM10 net36 ckb net52 VNW pm1p2_svt_lp W=150e-9 L=60e-9 MR=1
MPM9 net52 net39 VDD VNW pm1p2_svt_lp W=150e-9 L=60e-9 MR=1
MPM_RN2 net39 RN VDD VNW pm1p2_svt_lp W=300e-9 L=60e-9 MR=1
MPM8 net39 net36 VDD VNW pm1p2_svt_lp W=300e-9 L=60e-9 MR=1
MPM7 net36 ckn net33 VNW pm1p2_svt_lp W=300e-9 L=60e-9 MR=1
MPM6 net24 ckn net46 VNW pm1p2_svt_lp W=150e-9 L=60e-9 MR=1
MPM_RN net46 RN VDD VNW pm1p2_svt_lp W=150e-9 L=60e-9 MR=1
MPM5 net46 net33 VDD VNW pm1p2_svt_lp W=150e-9 L=60e-9 MR=1
MPM4 net33 net24 VDD VNW pm1p2_svt_lp W=300e-9 L=60e-9 MR=1
MPM_SE0 sen SE VDD VNW pm1p2_svt_lp W=300e-9 L=60e-9 MR=1
MPM3 net24 ckb net20 VNW pm1p2_svt_lp W=300e-9 L=60e-9 MR=1
MPMR2 net58 SI VDD VNW pm1p2_svt_lp W=300e-9 L=60e-9 MR=1
MPML2 net59 D VDD VNW pm1p2_svt_lp W=300e-9 L=60e-9 MR=1
MPM_SE2 net20 sen net58 VNW pm1p2_svt_lp W=300e-9 L=60e-9 MR=1
MPM_SE1 net20 SE net59 VNW pm1p2_svt_lp W=300e-9 L=60e-9 MR=1
MPM1 ckb ckn VDD VNW pm1p2_svt_lp W=300e-9 L=60e-9 MR=1
MPM0 ckn CK VDD VNW pm1p2_svt_lp W=300e-9 L=60e-9 MR=1
.ENDS
.SUBCKT SDFFRNQX1_9TSVT CK D Q RN SE SI VDD VSS VNW VPW
MNM11 Q net39 VSS VPW nm1p2_svt_lp W=470e-9 L=60e-9 MR=1
MNM9 net51 net39 VSS VPW nm1p2_svt_lp W=150e-9 L=60e-9 MR=1
MNM10 net36 ckn net51 VPW nm1p2_svt_lp W=150e-9 L=60e-9 MR=1
MNM_RN2 net53 RN VSS VPW nm1p2_svt_lp W=470e-9 L=60e-9 MR=1
MNM8 net39 net36 net53 VPW nm1p2_svt_lp W=470e-9 L=60e-9 MR=1
MNM7 net36 ckb net33 VPW nm1p2_svt_lp W=470e-9 L=60e-9 MR=1
MNM_RN net54 RN VSS VPW nm1p2_svt_lp W=150e-9 L=60e-9 MR=1
MNM5 net55 net33 net54 VPW nm1p2_svt_lp W=150e-9 L=60e-9 MR=1
MNM6 net24 ckb net55 VPW nm1p2_svt_lp W=150e-9 L=60e-9 MR=1
MNM4 net33 net24 VSS VPW nm1p2_svt_lp W=350e-9 L=60e-9 MR=1
MNM_SE0 sen SE VSS VPW nm1p2_svt_lp W=230e-9 L=60e-9 MR=1
MNMR2 net56 SI VSS VPW nm1p2_svt_lp W=470e-9 L=60e-9 MR=1
MNML2 net57 D VSS VPW nm1p2_svt_lp W=470e-9 L=60e-9 MR=1
MNM_SE2 net20 SE net56 VPW nm1p2_svt_lp W=470e-9 L=60e-9 MR=1
MNM_SE1 net20 sen net57 VPW nm1p2_svt_lp W=470e-9 L=60e-9 MR=1
MNM3 net24 ckn net20 VPW nm1p2_svt_lp W=470e-9 L=60e-9 MR=1
MNM1 ckb ckn VSS VPW nm1p2_svt_lp W=230e-9 L=60e-9 MR=1
MNM0 ckn CK VSS VPW nm1p2_svt_lp W=230e-9 L=60e-9 MR=1
MPM11 Q net39 VDD VNW pm1p2_svt_lp W=590e-9 L=60e-9 MR=1
MPM10 net36 ckb net52 VNW pm1p2_svt_lp W=150e-9 L=60e-9 MR=1
MPM9 net52 net39 VDD VNW pm1p2_svt_lp W=150e-9 L=60e-9 MR=1
MPM_RN2 net39 RN VDD VNW pm1p2_svt_lp W=590e-9 L=60e-9 MR=1
MPM8 net39 net36 VDD VNW pm1p2_svt_lp W=590e-9 L=60e-9 MR=1
MPM7 net36 ckn net33 VNW pm1p2_svt_lp W=590e-9 L=60e-9 MR=1
MPM6 net24 ckn net46 VNW pm1p2_svt_lp W=150e-9 L=60e-9 MR=1
MPM_RN net46 RN VDD VNW pm1p2_svt_lp W=150e-9 L=60e-9 MR=1
MPM5 net46 net33 VDD VNW pm1p2_svt_lp W=150e-9 L=60e-9 MR=1
MPM4 net33 net24 VDD VNW pm1p2_svt_lp W=370e-9 L=60e-9 MR=1
MPM_SE0 sen SE VDD VNW pm1p2_svt_lp W=300e-9 L=60e-9 MR=1
MPM3 net24 ckb net20 VNW pm1p2_svt_lp W=590e-9 L=60e-9 MR=1
MPMR2 net58 SI VDD VNW pm1p2_svt_lp W=590e-9 L=60e-9 MR=1
MPML2 net59 D VDD VNW pm1p2_svt_lp W=590e-9 L=60e-9 MR=1
MPM_SE2 net20 sen net58 VNW pm1p2_svt_lp W=590e-9 L=60e-9 MR=1
MPM_SE1 net20 SE net59 VNW pm1p2_svt_lp W=590e-9 L=60e-9 MR=1
MPM1 ckb ckn VDD VNW pm1p2_svt_lp W=300e-9 L=60e-9 MR=1
MPM0 ckn CK VDD VNW pm1p2_svt_lp W=300e-9 L=60e-9 MR=1
.ENDS
.SUBCKT SDFFRNQX2_9TSVT CK D Q RN SE SI VDD VSS VNW VPW
MNM11 Q net39 VSS VPW nm1p2_svt_lp W=940e-9 L=60e-9 MR=1
MNM9 net51 net39 VSS VPW nm1p2_svt_lp W=150e-9 L=60e-9 MR=1
MNM10 net36 ckn net51 VPW nm1p2_svt_lp W=150e-9 L=60e-9 MR=1
MNM_RN2 net53 RN VSS VPW nm1p2_svt_lp W=470e-9 L=60e-9 MR=1
MNM8 net39 net36 net53 VPW nm1p2_svt_lp W=470e-9 L=60e-9 MR=1
MNM7 net36 ckb net33 VPW nm1p2_svt_lp W=470e-9 L=60e-9 MR=1
MNM_RN net54 RN VSS VPW nm1p2_svt_lp W=150e-9 L=60e-9 MR=1
MNM5 net55 net33 net54 VPW nm1p2_svt_lp W=150e-9 L=60e-9 MR=1
MNM6 net24 ckb net55 VPW nm1p2_svt_lp W=150e-9 L=60e-9 MR=1
MNM4 net33 net24 VSS VPW nm1p2_svt_lp W=350e-9 L=60e-9 MR=1
MNM_SE0 sen SE VSS VPW nm1p2_svt_lp W=230e-9 L=60e-9 MR=1
MNMR2 net56 SI VSS VPW nm1p2_svt_lp W=470e-9 L=60e-9 MR=1
MNML2 net57 D VSS VPW nm1p2_svt_lp W=470e-9 L=60e-9 MR=1
MNM_SE2 net20 SE net56 VPW nm1p2_svt_lp W=470e-9 L=60e-9 MR=1
MNM_SE1 net20 sen net57 VPW nm1p2_svt_lp W=470e-9 L=60e-9 MR=1
MNM3 net24 ckn net20 VPW nm1p2_svt_lp W=470e-9 L=60e-9 MR=1
MNM1 ckb ckn VSS VPW nm1p2_svt_lp W=230e-9 L=60e-9 MR=1
MNM0 ckn CK VSS VPW nm1p2_svt_lp W=230e-9 L=60e-9 MR=1
MPM11 Q net39 VDD VNW pm1p2_svt_lp W=1.18e-6 L=60e-9 MR=1
MPM10 net36 ckb net52 VNW pm1p2_svt_lp W=150e-9 L=60e-9 MR=1
MPM9 net52 net39 VDD VNW pm1p2_svt_lp W=150e-9 L=60e-9 MR=1
MPM_RN2 net39 RN VDD VNW pm1p2_svt_lp W=590e-9 L=60e-9 MR=1
MPM8 net39 net36 VDD VNW pm1p2_svt_lp W=590e-9 L=60e-9 MR=1
MPM7 net36 ckn net33 VNW pm1p2_svt_lp W=590e-9 L=60e-9 MR=1
MPM6 net24 ckn net46 VNW pm1p2_svt_lp W=150e-9 L=60e-9 MR=1
MPM_RN net46 RN VDD VNW pm1p2_svt_lp W=150e-9 L=60e-9 MR=1
MPM5 net46 net33 VDD VNW pm1p2_svt_lp W=150e-9 L=60e-9 MR=1
MPM4 net33 net24 VDD VNW pm1p2_svt_lp W=370e-9 L=60e-9 MR=1
MPM_SE0 sen SE VDD VNW pm1p2_svt_lp W=300e-9 L=60e-9 MR=1
MPM3 net24 ckb net20 VNW pm1p2_svt_lp W=590e-9 L=60e-9 MR=1
MPMR2 net58 SI VDD VNW pm1p2_svt_lp W=590e-9 L=60e-9 MR=1
MPML2 net59 D VDD VNW pm1p2_svt_lp W=590e-9 L=60e-9 MR=1
MPM_SE2 net20 sen net58 VNW pm1p2_svt_lp W=590e-9 L=60e-9 MR=1
MPM_SE1 net20 SE net59 VNW pm1p2_svt_lp W=590e-9 L=60e-9 MR=1
MPM1 ckb ckn VDD VNW pm1p2_svt_lp W=300e-9 L=60e-9 MR=1
MPM0 ckn CK VDD VNW pm1p2_svt_lp W=300e-9 L=60e-9 MR=1
.ENDS
.SUBCKT SDFFRNQX4_9TSVT CK D Q RN SE SI VDD VSS VNW VPW
MNM11 Q net39 VSS VPW nm1p2_svt_lp W=1.88e-6 L=60e-9 MR=1
MNM9 net51 net39 VSS VPW nm1p2_svt_lp W=150e-9 L=60e-9 MR=1
MNM10 net36 ckn net51 VPW nm1p2_svt_lp W=150e-9 L=60e-9 MR=1
MNM_RN2 net53 RN VSS VPW nm1p2_svt_lp W=940e-9 L=60e-9 MR=1
MNM8 net39 net36 net53 VPW nm1p2_svt_lp W=940e-9 L=60e-9 MR=1
MNM7 net36 ckb net33 VPW nm1p2_svt_lp W=470e-9 L=60e-9 MR=1
MNM_RN net54 RN VSS VPW nm1p2_svt_lp W=150e-9 L=60e-9 MR=1
MNM5 net55 net33 net54 VPW nm1p2_svt_lp W=150e-9 L=60e-9 MR=1
MNM6 net24 ckb net55 VPW nm1p2_svt_lp W=150e-9 L=60e-9 MR=1
MNM4 net33 net24 VSS VPW nm1p2_svt_lp W=350e-9 L=60e-9 MR=1
MNM_SE0 sen SE VSS VPW nm1p2_svt_lp W=230e-9 L=60e-9 MR=1
MNMR2 net56 SI VSS VPW nm1p2_svt_lp W=470e-9 L=60e-9 MR=1
MNML2 net57 D VSS VPW nm1p2_svt_lp W=470e-9 L=60e-9 MR=1
MNM_SE2 net20 SE net56 VPW nm1p2_svt_lp W=470e-9 L=60e-9 MR=1
MNM_SE1 net20 sen net57 VPW nm1p2_svt_lp W=470e-9 L=60e-9 MR=1
MNM3 net24 ckn net20 VPW nm1p2_svt_lp W=470e-9 L=60e-9 MR=1
MNM1 ckb ckn VSS VPW nm1p2_svt_lp W=470e-9 L=60e-9 MR=1
MNM0 ckn CK VSS VPW nm1p2_svt_lp W=470e-9 L=60e-9 MR=1
MPM11 Q net39 VDD VNW pm1p2_svt_lp W=2.36e-6 L=60e-9 MR=1
MPM10 net36 ckb net52 VNW pm1p2_svt_lp W=150e-9 L=60e-9 MR=1
MPM9 net52 net39 VDD VNW pm1p2_svt_lp W=150e-9 L=60e-9 MR=1
MPM_RN2 net39 RN VDD VNW pm1p2_svt_lp W=1.18e-6 L=60e-9 MR=1
MPM8 net39 net36 VDD VNW pm1p2_svt_lp W=1.18e-6 L=60e-9 MR=1
MPM7 net36 ckn net33 VNW pm1p2_svt_lp W=590e-9 L=60e-9 MR=1
MPM6 net24 ckn net46 VNW pm1p2_svt_lp W=150e-9 L=60e-9 MR=1
MPM_RN net46 RN VDD VNW pm1p2_svt_lp W=150e-9 L=60e-9 MR=1
MPM5 net46 net33 VDD VNW pm1p2_svt_lp W=150e-9 L=60e-9 MR=1
MPM4 net33 net24 VDD VNW pm1p2_svt_lp W=370e-9 L=60e-9 MR=1
MPM_SE0 sen SE VDD VNW pm1p2_svt_lp W=300e-9 L=60e-9 MR=1
MPM3 net24 ckb net20 VNW pm1p2_svt_lp W=590e-9 L=60e-9 MR=1
MPMR2 net58 SI VDD VNW pm1p2_svt_lp W=590e-9 L=60e-9 MR=1
MPML2 net59 D VDD VNW pm1p2_svt_lp W=590e-9 L=60e-9 MR=1
MPM_SE2 net20 sen net58 VNW pm1p2_svt_lp W=590e-9 L=60e-9 MR=1
MPM_SE1 net20 SE net59 VNW pm1p2_svt_lp W=590e-9 L=60e-9 MR=1
MPM1 ckb ckn VDD VNW pm1p2_svt_lp W=590e-9 L=60e-9 MR=1
MPM0 ckn CK VDD VNW pm1p2_svt_lp W=390e-9 L=60e-9 MR=1
.ENDS
.SUBCKT SDFFRSNQX0P5_9TSVT CK D Q RN SE SI SN VDD VSS VNW VPW
MNM11 Q net40 VSS VPW nm1p2_svt_lp W=230e-9 L=60e-9 MR=1
MNM9 net56 net40 VSS VPW nm1p2_svt_lp W=150e-9 L=60e-9 MR=1
MNM_SN2 net57 SN net56 VPW nm1p2_svt_lp W=150e-9 L=60e-9 MR=1
MNM10 net37 ckn net57 VPW nm1p2_svt_lp W=150e-9 L=60e-9 MR=1
MNM_RN2 net58 RN VSS VPW nm1p2_svt_lp W=230e-9 L=60e-9 MR=1
MNM8 net40 net37 net58 VPW nm1p2_svt_lp W=230e-9 L=60e-9 MR=1
MNM7 net37 ckb net32 VPW nm1p2_svt_lp W=230e-9 L=60e-9 MR=1
MNM_RN net59 RN VSS VPW nm1p2_svt_lp W=150e-9 L=60e-9 MR=1
MNM5 net60 net32 net59 VPW nm1p2_svt_lp W=150e-9 L=60e-9 MR=1
MNM6 net26 ckb net60 VPW nm1p2_svt_lp W=150e-9 L=60e-9 MR=1
MNM4 net61 net26 VSS VPW nm1p2_svt_lp W=230e-9 L=60e-9 MR=1
MNM_SN net32 SN net61 VPW nm1p2_svt_lp W=230e-9 L=60e-9 MR=1
MNM_SE0 sen SE VSS VPW nm1p2_svt_lp W=230e-9 L=60e-9 MR=1
MNMR2 net62 SI VSS VPW nm1p2_svt_lp W=230e-9 L=60e-9 MR=1
MNML2 net63 D VSS VPW nm1p2_svt_lp W=230e-9 L=60e-9 MR=1
MNM_SE2 net22 SE net62 VPW nm1p2_svt_lp W=230e-9 L=60e-9 MR=1
MNM_SE1 net22 sen net63 VPW nm1p2_svt_lp W=230e-9 L=60e-9 MR=1
MNM3 net26 ckn net22 VPW nm1p2_svt_lp W=230e-9 L=60e-9 MR=1
MNM1 ckb ckn VSS VPW nm1p2_svt_lp W=230e-9 L=60e-9 MR=1
MNM0 ckn CK VSS VPW nm1p2_svt_lp W=230e-9 L=60e-9 MR=1
MPM11 Q net40 VDD VNW pm1p2_svt_lp W=300e-9 L=60e-9 MR=1
MPM10 net37 ckb net54 VNW pm1p2_svt_lp W=150e-9 L=60e-9 MR=1
MPM_SN2 net54 SN VDD VNW pm1p2_svt_lp W=150e-9 L=60e-9 MR=1
MPM9 net54 net40 VDD VNW pm1p2_svt_lp W=150e-9 L=60e-9 MR=1
MPM_RN2 net40 RN VDD VNW pm1p2_svt_lp W=300e-9 L=60e-9 MR=1
MPM8 net40 net37 VDD VNW pm1p2_svt_lp W=300e-9 L=60e-9 MR=1
MPM7 net37 ckn net32 VNW pm1p2_svt_lp W=300e-9 L=60e-9 MR=1
MPM6 net26 ckn net49 VNW pm1p2_svt_lp W=150e-9 L=60e-9 MR=1
MPM_RN net49 RN VDD VNW pm1p2_svt_lp W=150e-9 L=60e-9 MR=1
MPM5 net49 net32 VDD VNW pm1p2_svt_lp W=150e-9 L=60e-9 MR=1
MPM_SN net32 SN VDD VNW pm1p2_svt_lp W=300e-9 L=60e-9 MR=1
MPM4 net32 net26 VDD VNW pm1p2_svt_lp W=300e-9 L=60e-9 MR=1
MPM_SE0 sen SE VDD VNW pm1p2_svt_lp W=300e-9 L=60e-9 MR=1
MPM3 net26 ckb net22 VNW pm1p2_svt_lp W=300e-9 L=60e-9 MR=1
MPMR2 net64 SI VDD VNW pm1p2_svt_lp W=300e-9 L=60e-9 MR=1
MPML2 net65 D VDD VNW pm1p2_svt_lp W=300e-9 L=60e-9 MR=1
MPM_SE2 net22 sen net64 VNW pm1p2_svt_lp W=300e-9 L=60e-9 MR=1
MPM_SE1 net22 SE net65 VNW pm1p2_svt_lp W=300e-9 L=60e-9 MR=1
MPM1 ckb ckn VDD VNW pm1p2_svt_lp W=300e-9 L=60e-9 MR=1
MPM0 ckn CK VDD VNW pm1p2_svt_lp W=300e-9 L=60e-9 MR=1
.ENDS
.SUBCKT SDFFRSNQX1_9TSVT CK D Q RN SE SI SN VDD VSS VNW VPW
MNM11 Q net40 VSS VPW nm1p2_svt_lp W=470e-9 L=60e-9 MR=1
MNM9 net56 net40 VSS VPW nm1p2_svt_lp W=150e-9 L=60e-9 MR=1
MNM_SN2 net57 SN net56 VPW nm1p2_svt_lp W=150e-9 L=60e-9 MR=1
MNM10 net37 ckn net57 VPW nm1p2_svt_lp W=150e-9 L=60e-9 MR=1
MNM_RN2 net58 RN VSS VPW nm1p2_svt_lp W=470e-9 L=60e-9 MR=1
MNM8 net40 net37 net58 VPW nm1p2_svt_lp W=470e-9 L=60e-9 MR=1
MNM7 net37 ckb net32 VPW nm1p2_svt_lp W=290e-9 L=60e-9 MR=1
MNM_RN net59 RN VSS VPW nm1p2_svt_lp W=150e-9 L=60e-9 MR=1
MNM5 net60 net32 net59 VPW nm1p2_svt_lp W=150e-9 L=60e-9 MR=1
MNM6 net26 ckb net60 VPW nm1p2_svt_lp W=150e-9 L=60e-9 MR=1
MNM4 net61 net26 VSS VPW nm1p2_svt_lp W=470e-9 L=60e-9 MR=1
MNM_SN net32 SN net61 VPW nm1p2_svt_lp W=470e-9 L=60e-9 MR=1
MNM_SE0 sen SE VSS VPW nm1p2_svt_lp W=230e-9 L=60e-9 MR=1
MNMR2 net62 SI VSS VPW nm1p2_svt_lp W=470e-9 L=60e-9 MR=1
MNML2 net63 D VSS VPW nm1p2_svt_lp W=470e-9 L=60e-9 MR=1
MNM_SE2 net22 SE net62 VPW nm1p2_svt_lp W=470e-9 L=60e-9 MR=1
MNM_SE1 net22 sen net63 VPW nm1p2_svt_lp W=470e-9 L=60e-9 MR=1
MNM3 net26 ckn net22 VPW nm1p2_svt_lp W=470e-9 L=60e-9 MR=1
MNM1 ckb ckn VSS VPW nm1p2_svt_lp W=230e-9 L=60e-9 MR=1
MNM0 ckn CK VSS VPW nm1p2_svt_lp W=230e-9 L=60e-9 MR=1
MPM11 Q net40 VDD VNW pm1p2_svt_lp W=590e-9 L=60e-9 MR=1
MPM10 net37 ckb net54 VNW pm1p2_svt_lp W=150e-9 L=60e-9 MR=1
MPM_SN2 net54 SN VDD VNW pm1p2_svt_lp W=150e-9 L=60e-9 MR=1
MPM9 net54 net40 VDD VNW pm1p2_svt_lp W=150e-9 L=60e-9 MR=1
MPM_RN2 net40 RN VDD VNW pm1p2_svt_lp W=590e-9 L=60e-9 MR=1
MPM8 net40 net37 VDD VNW pm1p2_svt_lp W=590e-9 L=60e-9 MR=1
MPM7 net37 ckn net32 VNW pm1p2_svt_lp W=590e-9 L=60e-9 MR=1
MPM6 net26 ckn net49 VNW pm1p2_svt_lp W=150e-9 L=60e-9 MR=1
MPM_RN net49 RN VDD VNW pm1p2_svt_lp W=150e-9 L=60e-9 MR=1
MPM5 net49 net32 VDD VNW pm1p2_svt_lp W=150e-9 L=60e-9 MR=1
MPM_SN net32 SN VDD VNW pm1p2_svt_lp W=370e-9 L=60e-9 MR=1
MPM4 net32 net26 VDD VNW pm1p2_svt_lp W=390e-9 L=60e-9 MR=1
MPM_SE0 sen SE VDD VNW pm1p2_svt_lp W=300e-9 L=60e-9 MR=1
MPM3 net26 ckb net22 VNW pm1p2_svt_lp W=590e-9 L=60e-9 MR=1
MPMR2 net64 SI VDD VNW pm1p2_svt_lp W=590e-9 L=60e-9 MR=1
MPML2 net65 D VDD VNW pm1p2_svt_lp W=590e-9 L=60e-9 MR=1
MPM_SE2 net22 sen net64 VNW pm1p2_svt_lp W=590e-9 L=60e-9 MR=1
MPM_SE1 net22 SE net65 VNW pm1p2_svt_lp W=590e-9 L=60e-9 MR=1
MPM1 ckb ckn VDD VNW pm1p2_svt_lp W=300e-9 L=60e-9 MR=1
MPM0 ckn CK VDD VNW pm1p2_svt_lp W=300e-9 L=60e-9 MR=1
.ENDS
.SUBCKT SDFFRSNQX2_9TSVT CK D Q RN SE SI SN VDD VSS VNW VPW
MNM11 Q net40 VSS VPW nm1p2_svt_lp W=940e-9 L=60e-9 MR=1
MNM9 net56 net40 VSS VPW nm1p2_svt_lp W=150e-9 L=60e-9 MR=1
MNM_SN2 net57 SN net56 VPW nm1p2_svt_lp W=150e-9 L=60e-9 MR=1
MNM10 net37 ckn net57 VPW nm1p2_svt_lp W=150e-9 L=60e-9 MR=1
MNM_RN2 net58 RN VSS VPW nm1p2_svt_lp W=470e-9 L=60e-9 MR=1
MNM8 net40 net37 net58 VPW nm1p2_svt_lp W=470e-9 L=60e-9 MR=1
MNM7 net37 ckb net32 VPW nm1p2_svt_lp W=290e-9 L=60e-9 MR=1
MNM_RN net59 RN VSS VPW nm1p2_svt_lp W=150e-9 L=60e-9 MR=1
MNM5 net60 net32 net59 VPW nm1p2_svt_lp W=150e-9 L=60e-9 MR=1
MNM6 net26 ckb net60 VPW nm1p2_svt_lp W=150e-9 L=60e-9 MR=1
MNM4 net61 net26 VSS VPW nm1p2_svt_lp W=470e-9 L=60e-9 MR=1
MNM_SN net32 SN net61 VPW nm1p2_svt_lp W=470e-9 L=60e-9 MR=1
MNM_SE0 sen SE VSS VPW nm1p2_svt_lp W=230e-9 L=60e-9 MR=1
MNMR2 net62 SI VSS VPW nm1p2_svt_lp W=470e-9 L=60e-9 MR=1
MNML2 net63 D VSS VPW nm1p2_svt_lp W=470e-9 L=60e-9 MR=1
MNM_SE2 net22 SE net62 VPW nm1p2_svt_lp W=470e-9 L=60e-9 MR=1
MNM_SE1 net22 sen net63 VPW nm1p2_svt_lp W=470e-9 L=60e-9 MR=1
MNM3 net26 ckn net22 VPW nm1p2_svt_lp W=470e-9 L=60e-9 MR=1
MNM1 ckb ckn VSS VPW nm1p2_svt_lp W=230e-9 L=60e-9 MR=1
MNM0 ckn CK VSS VPW nm1p2_svt_lp W=230e-9 L=60e-9 MR=1
MPM11 Q net40 VDD VNW pm1p2_svt_lp W=1.18e-6 L=60e-9 MR=1
MPM10 net37 ckb net54 VNW pm1p2_svt_lp W=150e-9 L=60e-9 MR=1
MPM_SN2 net54 SN VDD VNW pm1p2_svt_lp W=150e-9 L=60e-9 MR=1
MPM9 net54 net40 VDD VNW pm1p2_svt_lp W=150e-9 L=60e-9 MR=1
MPM_RN2 net40 RN VDD VNW pm1p2_svt_lp W=590e-9 L=60e-9 MR=1
MPM8 net40 net37 VDD VNW pm1p2_svt_lp W=590e-9 L=60e-9 MR=1
MPM7 net37 ckn net32 VNW pm1p2_svt_lp W=590e-9 L=60e-9 MR=1
MPM6 net26 ckn net49 VNW pm1p2_svt_lp W=150e-9 L=60e-9 MR=1
MPM_RN net49 RN VDD VNW pm1p2_svt_lp W=150e-9 L=60e-9 MR=1
MPM5 net49 net32 VDD VNW pm1p2_svt_lp W=150e-9 L=60e-9 MR=1
MPM_SN net32 SN VDD VNW pm1p2_svt_lp W=370e-9 L=60e-9 MR=1
MPM4 net32 net26 VDD VNW pm1p2_svt_lp W=390e-9 L=60e-9 MR=1
MPM_SE0 sen SE VDD VNW pm1p2_svt_lp W=300e-9 L=60e-9 MR=1
MPM3 net26 ckb net22 VNW pm1p2_svt_lp W=590e-9 L=60e-9 MR=1
MPMR2 net64 SI VDD VNW pm1p2_svt_lp W=590e-9 L=60e-9 MR=1
MPML2 net65 D VDD VNW pm1p2_svt_lp W=590e-9 L=60e-9 MR=1
MPM_SE2 net22 sen net64 VNW pm1p2_svt_lp W=590e-9 L=60e-9 MR=1
MPM_SE1 net22 SE net65 VNW pm1p2_svt_lp W=590e-9 L=60e-9 MR=1
MPM1 ckb ckn VDD VNW pm1p2_svt_lp W=300e-9 L=60e-9 MR=1
MPM0 ckn CK VDD VNW pm1p2_svt_lp W=300e-9 L=60e-9 MR=1
.ENDS
.SUBCKT SDFFRSNQX4_9TSVT CK D Q RN SE SI SN VDD VSS VNW VPW
MNM11 Q net40 VSS VPW nm1p2_svt_lp W=1.88e-6 L=60e-9 MR=1
MNM9 net56 net40 VSS VPW nm1p2_svt_lp W=150e-9 L=60e-9 MR=1
MNM_SN2 net57 SN net56 VPW nm1p2_svt_lp W=150e-9 L=60e-9 MR=1
MNM10 net37 ckn net57 VPW nm1p2_svt_lp W=150e-9 L=60e-9 MR=1
MNM_RN2 net58 RN VSS VPW nm1p2_svt_lp W=940e-9 L=60e-9 MR=1
MNM8 net40 net37 net58 VPW nm1p2_svt_lp W=940e-9 L=60e-9 MR=1
MNM7 net37 ckb net32 VPW nm1p2_svt_lp W=290e-9 L=60e-9 MR=1
MNM_RN net59 RN VSS VPW nm1p2_svt_lp W=150e-9 L=60e-9 MR=1
MNM5 net60 net32 net59 VPW nm1p2_svt_lp W=150e-9 L=60e-9 MR=1
MNM6 net26 ckb net60 VPW nm1p2_svt_lp W=150e-9 L=60e-9 MR=1
MNM4 net61 net26 VSS VPW nm1p2_svt_lp W=470e-9 L=60e-9 MR=1
MNM_SN net32 SN net61 VPW nm1p2_svt_lp W=470e-9 L=60e-9 MR=1
MNM_SE0 sen SE VSS VPW nm1p2_svt_lp W=230e-9 L=60e-9 MR=1
MNMR2 net62 SI VSS VPW nm1p2_svt_lp W=470e-9 L=60e-9 MR=1
MNML2 net63 D VSS VPW nm1p2_svt_lp W=470e-9 L=60e-9 MR=1
MNM_SE2 net22 SE net62 VPW nm1p2_svt_lp W=470e-9 L=60e-9 MR=1
MNM_SE1 net22 sen net63 VPW nm1p2_svt_lp W=470e-9 L=60e-9 MR=1
MNM3 net26 ckn net22 VPW nm1p2_svt_lp W=470e-9 L=60e-9 MR=1
MNM1 ckb ckn VSS VPW nm1p2_svt_lp W=470e-9 L=60e-9 MR=1
MNM0 ckn CK VSS VPW nm1p2_svt_lp W=470e-9 L=60e-9 MR=1
MPM11 Q net40 VDD VNW pm1p2_svt_lp W=2.36e-6 L=60e-9 MR=1
MPM10 net37 ckb net54 VNW pm1p2_svt_lp W=150e-9 L=60e-9 MR=1
MPM_SN2 net54 SN VDD VNW pm1p2_svt_lp W=150e-9 L=60e-9 MR=1
MPM9 net54 net40 VDD VNW pm1p2_svt_lp W=150e-9 L=60e-9 MR=1
MPM_RN2 net40 RN VDD VNW pm1p2_svt_lp W=1.18e-6 L=60e-9 MR=1
MPM8 net40 net37 VDD VNW pm1p2_svt_lp W=1.18e-6 L=60e-9 MR=1
MPM7 net37 ckn net32 VNW pm1p2_svt_lp W=590e-9 L=60e-9 MR=1
MPM6 net26 ckn net49 VNW pm1p2_svt_lp W=150e-9 L=60e-9 MR=1
MPM_RN net49 RN VDD VNW pm1p2_svt_lp W=150e-9 L=60e-9 MR=1
MPM5 net49 net32 VDD VNW pm1p2_svt_lp W=150e-9 L=60e-9 MR=1
MPM_SN net32 SN VDD VNW pm1p2_svt_lp W=370e-9 L=60e-9 MR=1
MPM4 net32 net26 VDD VNW pm1p2_svt_lp W=390e-9 L=60e-9 MR=1
MPM_SE0 sen SE VDD VNW pm1p2_svt_lp W=300e-9 L=60e-9 MR=1
MPM3 net26 ckb net22 VNW pm1p2_svt_lp W=590e-9 L=60e-9 MR=1
MPMR2 net64 SI VDD VNW pm1p2_svt_lp W=590e-9 L=60e-9 MR=1
MPML2 net65 D VDD VNW pm1p2_svt_lp W=590e-9 L=60e-9 MR=1
MPM_SE2 net22 sen net64 VNW pm1p2_svt_lp W=590e-9 L=60e-9 MR=1
MPM_SE1 net22 SE net65 VNW pm1p2_svt_lp W=590e-9 L=60e-9 MR=1
MPM1 ckb ckn VDD VNW pm1p2_svt_lp W=590e-9 L=60e-9 MR=1
MPM0 ckn CK VDD VNW pm1p2_svt_lp W=390e-9 L=60e-9 MR=1
.ENDS
.SUBCKT SDFFSNQX0P5_9TSVT CK D Q SE SI SN VDD VSS VNW VPW
MNM11 Q net41 VSS VPW nm1p2_svt_lp W=230e-9 L=60e-9 MR=1
MNM9 net51 net41 VSS VPW nm1p2_svt_lp W=150e-9 L=60e-9 MR=1
MNM_SN2 net52 SN net51 VPW nm1p2_svt_lp W=150e-9 L=60e-9 MR=1
MNM10 net35 ckn net52 VPW nm1p2_svt_lp W=150e-9 L=60e-9 MR=1
MNM8 net41 net35 VSS VPW nm1p2_svt_lp W=230e-9 L=60e-9 MR=1
MNM7 net35 ckb net30 VPW nm1p2_svt_lp W=230e-9 L=60e-9 MR=1
MNM5 net53 net30 VSS VPW nm1p2_svt_lp W=150e-9 L=60e-9 MR=1
MNM6 net24 ckb net53 VPW nm1p2_svt_lp W=150e-9 L=60e-9 MR=1
MNM4 net55 net24 VSS VPW nm1p2_svt_lp W=230e-9 L=60e-9 MR=1
MNM_SN net30 SN net55 VPW nm1p2_svt_lp W=230e-9 L=60e-9 MR=1
MNM_SE0 sen SE VSS VPW nm1p2_svt_lp W=230e-9 L=60e-9 MR=1
MNMR2 net56 SI VSS VPW nm1p2_svt_lp W=230e-9 L=60e-9 MR=1
MNML2 net57 D VSS VPW nm1p2_svt_lp W=230e-9 L=60e-9 MR=1
MNM_SE2 net20 SE net56 VPW nm1p2_svt_lp W=230e-9 L=60e-9 MR=1
MNM_SE1 net20 sen net57 VPW nm1p2_svt_lp W=230e-9 L=60e-9 MR=1
MNM3 net24 ckn net20 VPW nm1p2_svt_lp W=230e-9 L=60e-9 MR=1
MNM1 ckb ckn VSS VPW nm1p2_svt_lp W=230e-9 L=60e-9 MR=1
MNM0 ckn CK VSS VPW nm1p2_svt_lp W=230e-9 L=60e-9 MR=1
MPM11 Q net41 VDD VNW pm1p2_svt_lp W=300e-9 L=60e-9 MR=1
MPM10 net35 ckb net49 VNW pm1p2_svt_lp W=150e-9 L=60e-9 MR=1
MPM_SN2 net49 SN VDD VNW pm1p2_svt_lp W=150e-9 L=60e-9 MR=1
MPM9 net49 net41 VDD VNW pm1p2_svt_lp W=150e-9 L=60e-9 MR=1
MPM8 net41 net35 VDD VNW pm1p2_svt_lp W=300e-9 L=60e-9 MR=1
MPM7 net35 ckn net30 VNW pm1p2_svt_lp W=300e-9 L=60e-9 MR=1
MPM6 net24 ckn net54 VNW pm1p2_svt_lp W=150e-9 L=60e-9 MR=1
MPM5 net54 net30 VDD VNW pm1p2_svt_lp W=150e-9 L=60e-9 MR=1
MPM_SN net30 SN VDD VNW pm1p2_svt_lp W=300e-9 L=60e-9 MR=1
MPM4 net30 net24 VDD VNW pm1p2_svt_lp W=300e-9 L=60e-9 MR=1
MPM_SE0 sen SE VDD VNW pm1p2_svt_lp W=300e-9 L=60e-9 MR=1
MPM3 net24 ckb net20 VNW pm1p2_svt_lp W=300e-9 L=60e-9 MR=1
MPMR2 net58 SI VDD VNW pm1p2_svt_lp W=300e-9 L=60e-9 MR=1
MPML2 net59 D VDD VNW pm1p2_svt_lp W=300e-9 L=60e-9 MR=1
MPM_SE2 net20 sen net58 VNW pm1p2_svt_lp W=300e-9 L=60e-9 MR=1
MPM_SE1 net20 SE net59 VNW pm1p2_svt_lp W=300e-9 L=60e-9 MR=1
MPM1 ckb ckn VDD VNW pm1p2_svt_lp W=300e-9 L=60e-9 MR=1
MPM0 ckn CK VDD VNW pm1p2_svt_lp W=300e-9 L=60e-9 MR=1
.ENDS
.SUBCKT SDFFSNQX1_9TSVT CK D Q SE SI SN VDD VSS VNW VPW
MNM11 Q net41 VSS VPW nm1p2_svt_lp W=470e-9 L=60e-9 MR=1
MNM9 net51 net41 VSS VPW nm1p2_svt_lp W=150e-9 L=60e-9 MR=1
MNM_SN2 net52 SN net51 VPW nm1p2_svt_lp W=150e-9 L=60e-9 MR=1
MNM10 net35 ckn net52 VPW nm1p2_svt_lp W=150e-9 L=60e-9 MR=1
MNM8 net41 net35 VSS VPW nm1p2_svt_lp W=470e-9 L=60e-9 MR=1
MNM7 net35 ckb net30 VPW nm1p2_svt_lp W=290e-9 L=60e-9 MR=1
MNM5 net53 net30 VSS VPW nm1p2_svt_lp W=150e-9 L=60e-9 MR=1
MNM6 net24 ckb net53 VPW nm1p2_svt_lp W=150e-9 L=60e-9 MR=1
MNM4 net55 net24 VSS VPW nm1p2_svt_lp W=470e-9 L=60e-9 MR=1
MNM_SN net30 SN net55 VPW nm1p2_svt_lp W=470e-9 L=60e-9 MR=1
MNM_SE0 sen SE VSS VPW nm1p2_svt_lp W=230e-9 L=60e-9 MR=1
MNMR2 net56 SI VSS VPW nm1p2_svt_lp W=470e-9 L=60e-9 MR=1
MNML2 net57 D VSS VPW nm1p2_svt_lp W=470e-9 L=60e-9 MR=1
MNM_SE2 net20 SE net56 VPW nm1p2_svt_lp W=470e-9 L=60e-9 MR=1
MNM_SE1 net20 sen net57 VPW nm1p2_svt_lp W=470e-9 L=60e-9 MR=1
MNM3 net24 ckn net20 VPW nm1p2_svt_lp W=470e-9 L=60e-9 MR=1
MNM1 ckb ckn VSS VPW nm1p2_svt_lp W=230e-9 L=60e-9 MR=1
MNM0 ckn CK VSS VPW nm1p2_svt_lp W=230e-9 L=60e-9 MR=1
MPM11 Q net41 VDD VNW pm1p2_svt_lp W=590e-9 L=60e-9 MR=1
MPM10 net35 ckb net49 VNW pm1p2_svt_lp W=150e-9 L=60e-9 MR=1
MPM_SN2 net49 SN VDD VNW pm1p2_svt_lp W=150e-9 L=60e-9 MR=1
MPM9 net49 net41 VDD VNW pm1p2_svt_lp W=150e-9 L=60e-9 MR=1
MPM8 net41 net35 VDD VNW pm1p2_svt_lp W=590e-9 L=60e-9 MR=1
MPM7 net35 ckn net30 VNW pm1p2_svt_lp W=590e-9 L=60e-9 MR=1
MPM6 net24 ckn net54 VNW pm1p2_svt_lp W=150e-9 L=60e-9 MR=1
MPM5 net54 net30 VDD VNW pm1p2_svt_lp W=150e-9 L=60e-9 MR=1
MPM_SN net30 SN VDD VNW pm1p2_svt_lp W=590e-9 L=60e-9 MR=1
MPM4 net30 net24 VDD VNW pm1p2_svt_lp W=590e-9 L=60e-9 MR=1
MPM_SE0 sen SE VDD VNW pm1p2_svt_lp W=300e-9 L=60e-9 MR=1
MPM3 net24 ckb net20 VNW pm1p2_svt_lp W=590e-9 L=60e-9 MR=1
MPMR2 net58 SI VDD VNW pm1p2_svt_lp W=590e-9 L=60e-9 MR=1
MPML2 net59 D VDD VNW pm1p2_svt_lp W=590e-9 L=60e-9 MR=1
MPM_SE2 net20 sen net58 VNW pm1p2_svt_lp W=590e-9 L=60e-9 MR=1
MPM_SE1 net20 SE net59 VNW pm1p2_svt_lp W=590e-9 L=60e-9 MR=1
MPM1 ckb ckn VDD VNW pm1p2_svt_lp W=300e-9 L=60e-9 MR=1
MPM0 ckn CK VDD VNW pm1p2_svt_lp W=300e-9 L=60e-9 MR=1
.ENDS
.SUBCKT SDFFSNQX2_9TSVT CK D Q SE SI SN VDD VSS VNW VPW
MNM11 Q net41 VSS VPW nm1p2_svt_lp W=940e-9 L=60e-9 MR=1
MNM9 net51 net41 VSS VPW nm1p2_svt_lp W=150e-9 L=60e-9 MR=1
MNM_SN2 net52 SN net51 VPW nm1p2_svt_lp W=150e-9 L=60e-9 MR=1
MNM10 net35 ckn net52 VPW nm1p2_svt_lp W=150e-9 L=60e-9 MR=1
MNM8 net41 net35 VSS VPW nm1p2_svt_lp W=470e-9 L=60e-9 MR=1
MNM7 net35 ckb net30 VPW nm1p2_svt_lp W=290e-9 L=60e-9 MR=1
MNM5 net53 net30 VSS VPW nm1p2_svt_lp W=150e-9 L=60e-9 MR=1
MNM6 net24 ckb net53 VPW nm1p2_svt_lp W=150e-9 L=60e-9 MR=1
MNM4 net55 net24 VSS VPW nm1p2_svt_lp W=470e-9 L=60e-9 MR=1
MNM_SN net30 SN net55 VPW nm1p2_svt_lp W=470e-9 L=60e-9 MR=1
MNM_SE0 sen SE VSS VPW nm1p2_svt_lp W=230e-9 L=60e-9 MR=1
MNMR2 net56 SI VSS VPW nm1p2_svt_lp W=470e-9 L=60e-9 MR=1
MNML2 net57 D VSS VPW nm1p2_svt_lp W=470e-9 L=60e-9 MR=1
MNM_SE2 net20 SE net56 VPW nm1p2_svt_lp W=470e-9 L=60e-9 MR=1
MNM_SE1 net20 sen net57 VPW nm1p2_svt_lp W=470e-9 L=60e-9 MR=1
MNM3 net24 ckn net20 VPW nm1p2_svt_lp W=470e-9 L=60e-9 MR=1
MNM1 ckb ckn VSS VPW nm1p2_svt_lp W=230e-9 L=60e-9 MR=1
MNM0 ckn CK VSS VPW nm1p2_svt_lp W=230e-9 L=60e-9 MR=1
MPM11 Q net41 VDD VNW pm1p2_svt_lp W=1.18e-6 L=60e-9 MR=1
MPM10 net35 ckb net49 VNW pm1p2_svt_lp W=150e-9 L=60e-9 MR=1
MPM_SN2 net49 SN VDD VNW pm1p2_svt_lp W=150e-9 L=60e-9 MR=1
MPM9 net49 net41 VDD VNW pm1p2_svt_lp W=150e-9 L=60e-9 MR=1
MPM8 net41 net35 VDD VNW pm1p2_svt_lp W=590e-9 L=60e-9 MR=1
MPM7 net35 ckn net30 VNW pm1p2_svt_lp W=590e-9 L=60e-9 MR=1
MPM6 net24 ckn net54 VNW pm1p2_svt_lp W=150e-9 L=60e-9 MR=1
MPM5 net54 net30 VDD VNW pm1p2_svt_lp W=150e-9 L=60e-9 MR=1
MPM_SN net30 SN VDD VNW pm1p2_svt_lp W=590e-9 L=60e-9 MR=1
MPM4 net30 net24 VDD VNW pm1p2_svt_lp W=590e-9 L=60e-9 MR=1
MPM_SE0 sen SE VDD VNW pm1p2_svt_lp W=300e-9 L=60e-9 MR=1
MPM3 net24 ckb net20 VNW pm1p2_svt_lp W=590e-9 L=60e-9 MR=1
MPMR2 net58 SI VDD VNW pm1p2_svt_lp W=590e-9 L=60e-9 MR=1
MPML2 net59 D VDD VNW pm1p2_svt_lp W=590e-9 L=60e-9 MR=1
MPM_SE2 net20 sen net58 VNW pm1p2_svt_lp W=590e-9 L=60e-9 MR=1
MPM_SE1 net20 SE net59 VNW pm1p2_svt_lp W=590e-9 L=60e-9 MR=1
MPM1 ckb ckn VDD VNW pm1p2_svt_lp W=300e-9 L=60e-9 MR=1
MPM0 ckn CK VDD VNW pm1p2_svt_lp W=300e-9 L=60e-9 MR=1
.ENDS
.SUBCKT SDFFSNQX4_9TSVT CK D Q SE SI SN VDD VSS VNW VPW
MNM11 Q net41 VSS VPW nm1p2_svt_lp W=1.88e-6 L=60e-9 MR=1
MNM9 net51 net41 VSS VPW nm1p2_svt_lp W=150e-9 L=60e-9 MR=1
MNM_SN2 net52 SN net51 VPW nm1p2_svt_lp W=150e-9 L=60e-9 MR=1
MNM10 net35 ckn net52 VPW nm1p2_svt_lp W=150e-9 L=60e-9 MR=1
MNM8 net41 net35 VSS VPW nm1p2_svt_lp W=940e-9 L=60e-9 MR=1
MNM7 net35 ckb net30 VPW nm1p2_svt_lp W=290e-9 L=60e-9 MR=1
MNM5 net53 net30 VSS VPW nm1p2_svt_lp W=150e-9 L=60e-9 MR=1
MNM6 net24 ckb net53 VPW nm1p2_svt_lp W=150e-9 L=60e-9 MR=1
MNM4 net55 net24 VSS VPW nm1p2_svt_lp W=470e-9 L=60e-9 MR=1
MNM_SN net30 SN net55 VPW nm1p2_svt_lp W=470e-9 L=60e-9 MR=1
MNM_SE0 sen SE VSS VPW nm1p2_svt_lp W=230e-9 L=60e-9 MR=1
MNMR2 net56 SI VSS VPW nm1p2_svt_lp W=470e-9 L=60e-9 MR=1
MNML2 net57 D VSS VPW nm1p2_svt_lp W=470e-9 L=60e-9 MR=1
MNM_SE2 net20 SE net56 VPW nm1p2_svt_lp W=470e-9 L=60e-9 MR=1
MNM_SE1 net20 sen net57 VPW nm1p2_svt_lp W=470e-9 L=60e-9 MR=1
MNM3 net24 ckn net20 VPW nm1p2_svt_lp W=470e-9 L=60e-9 MR=1
MNM1 ckb ckn VSS VPW nm1p2_svt_lp W=470e-9 L=60e-9 MR=1
MNM0 ckn CK VSS VPW nm1p2_svt_lp W=470e-9 L=60e-9 MR=1
MPM11 Q net41 VDD VNW pm1p2_svt_lp W=2.36e-6 L=60e-9 MR=1
MPM10 net35 ckb net49 VNW pm1p2_svt_lp W=150e-9 L=60e-9 MR=1
MPM_SN2 net49 SN VDD VNW pm1p2_svt_lp W=150e-9 L=60e-9 MR=1
MPM9 net49 net41 VDD VNW pm1p2_svt_lp W=150e-9 L=60e-9 MR=1
MPM8 net41 net35 VDD VNW pm1p2_svt_lp W=1.18e-6 L=60e-9 MR=1
MPM7 net35 ckn net30 VNW pm1p2_svt_lp W=590e-9 L=60e-9 MR=1
MPM6 net24 ckn net54 VNW pm1p2_svt_lp W=150e-9 L=60e-9 MR=1
MPM5 net54 net30 VDD VNW pm1p2_svt_lp W=150e-9 L=60e-9 MR=1
MPM_SN net30 SN VDD VNW pm1p2_svt_lp W=590e-9 L=60e-9 MR=1
MPM4 net30 net24 VDD VNW pm1p2_svt_lp W=590e-9 L=60e-9 MR=1
MPM_SE0 sen SE VDD VNW pm1p2_svt_lp W=300e-9 L=60e-9 MR=1
MPM3 net24 ckb net20 VNW pm1p2_svt_lp W=590e-9 L=60e-9 MR=1
MPMR2 net58 SI VDD VNW pm1p2_svt_lp W=590e-9 L=60e-9 MR=1
MPML2 net59 D VDD VNW pm1p2_svt_lp W=590e-9 L=60e-9 MR=1
MPM_SE2 net20 sen net58 VNW pm1p2_svt_lp W=590e-9 L=60e-9 MR=1
MPM_SE1 net20 SE net59 VNW pm1p2_svt_lp W=590e-9 L=60e-9 MR=1
MPM1 ckb ckn VDD VNW pm1p2_svt_lp W=590e-9 L=60e-9 MR=1
MPM0 ckn CK VDD VNW pm1p2_svt_lp W=390e-9 L=60e-9 MR=1
.ENDS
.SUBCKT SDFFXQX0P5_9TSVT CK D0 D1 Q S SE SI VDD VSS VNW VPW
MNM11 Q net49 VSS VPW nm1p2_svt_lp W=230e-9 L=60e-9 MR=1
MNM9 net55 net49 VSS VPW nm1p2_svt_lp W=150e-9 L=60e-9 MR=1
MNM10 net43 ckn net55 VPW nm1p2_svt_lp W=150e-9 L=60e-9 MR=1
MNM8 net49 net43 VSS VPW nm1p2_svt_lp W=230e-9 L=60e-9 MR=1
MNM7 net43 ckb net38 VPW nm1p2_svt_lp W=230e-9 L=60e-9 MR=1
MNM5 net57 net38 VSS VPW nm1p2_svt_lp W=150e-9 L=60e-9 MR=1
MNM6 net28 ckb net57 VPW nm1p2_svt_lp W=150e-9 L=60e-9 MR=1
MNM4 net38 net28 VSS VPW nm1p2_svt_lp W=230e-9 L=60e-9 MR=1
MNM_S_D sn S VSS VPW nm1p2_svt_lp W=230e-9 L=60e-9 MR=1
MNM_SE0 sen SE VSS VPW nm1p2_svt_lp W=230e-9 L=60e-9 MR=1
MNM_sen net20 sen VSS VPW nm1p2_svt_lp W=230e-9 L=60e-9 MR=1
MNMR2 net59 SI VSS VPW nm1p2_svt_lp W=230e-9 L=60e-9 MR=1
MNM_D1 net61 D1 net20 VPW nm1p2_svt_lp W=230e-9 L=60e-9 MR=1
MNM_D0 net60 D0 net20 VPW nm1p2_svt_lp W=230e-9 L=60e-9 MR=1
MNM_SE2 net23 SE net59 VPW nm1p2_svt_lp W=230e-9 L=60e-9 MR=1
MNM_sn net23 sn net61 VPW nm1p2_svt_lp W=230e-9 L=60e-9 MR=1
MNM_S net23 S net60 VPW nm1p2_svt_lp W=230e-9 L=60e-9 MR=1
MNM3 net28 ckn net23 VPW nm1p2_svt_lp W=230e-9 L=60e-9 MR=1
MNM1 ckb ckn VSS VPW nm1p2_svt_lp W=230e-9 L=60e-9 MR=1
MNM0 ckn CK VSS VPW nm1p2_svt_lp W=230e-9 L=60e-9 MR=1
MPM11 Q net49 VDD VNW pm1p2_svt_lp W=300e-9 L=60e-9 MR=1
MPM10 net43 ckb net56 VNW pm1p2_svt_lp W=150e-9 L=60e-9 MR=1
MPM9 net56 net49 VDD VNW pm1p2_svt_lp W=150e-9 L=60e-9 MR=1
MPM8 net49 net43 VDD VNW pm1p2_svt_lp W=300e-9 L=60e-9 MR=1
MPM7 net43 ckn net38 VNW pm1p2_svt_lp W=300e-9 L=60e-9 MR=1
MPM6 net28 ckn net58 VNW pm1p2_svt_lp W=150e-9 L=60e-9 MR=1
MPM5 net58 net38 VDD VNW pm1p2_svt_lp W=150e-9 L=60e-9 MR=1
MPM4 net38 net28 VDD VNW pm1p2_svt_lp W=300e-9 L=60e-9 MR=1
MPM_S_D sn S VDD VNW pm1p2_svt_lp W=300e-9 L=60e-9 MR=1
MPM_SE0 sen SE VDD VNW pm1p2_svt_lp W=300e-9 L=60e-9 MR=1
MPM3 net28 ckb net23 VNW pm1p2_svt_lp W=300e-9 L=60e-9 MR=1
MPM_SE1 net21 SE VDD VNW pm1p2_svt_lp W=300e-9 L=60e-9 MR=1
MPMR2 net62 SI VDD VNW pm1p2_svt_lp W=300e-9 L=60e-9 MR=1
MPM_D1 net64 D1 net21 VNW pm1p2_svt_lp W=300e-9 L=60e-9 MR=1
MPM_D0 net63 D0 net21 VNW pm1p2_svt_lp W=300e-9 L=60e-9 MR=1
MPM_SE2 net23 sen net62 VNW pm1p2_svt_lp W=300e-9 L=60e-9 MR=1
MPM_S net23 S net64 VNW pm1p2_svt_lp W=300e-9 L=60e-9 MR=1
MPM_sn net23 sn net63 VNW pm1p2_svt_lp W=300e-9 L=60e-9 MR=1
MPM1 ckb ckn VDD VNW pm1p2_svt_lp W=300e-9 L=60e-9 MR=1
MPM0 ckn CK VDD VNW pm1p2_svt_lp W=300e-9 L=60e-9 MR=1
.ENDS
.SUBCKT SDFFXQX1_9TSVT CK D0 D1 Q S SE SI VDD VSS VNW VPW
MNM11 Q net49 VSS VPW nm1p2_svt_lp W=470e-9 L=60e-9 MR=1
MNM9 net55 net49 VSS VPW nm1p2_svt_lp W=150e-9 L=60e-9 MR=1
MNM10 net43 ckn net55 VPW nm1p2_svt_lp W=150e-9 L=60e-9 MR=1
MNM8 net49 net43 VSS VPW nm1p2_svt_lp W=470e-9 L=60e-9 MR=1
MNM7 net43 ckb net38 VPW nm1p2_svt_lp W=470e-9 L=60e-9 MR=1
MNM5 net57 net38 VSS VPW nm1p2_svt_lp W=150e-9 L=60e-9 MR=1
MNM6 net28 ckb net57 VPW nm1p2_svt_lp W=150e-9 L=60e-9 MR=1
MNM4 net38 net28 VSS VPW nm1p2_svt_lp W=470e-9 L=60e-9 MR=1
MNM_S_D sn S VSS VPW nm1p2_svt_lp W=230e-9 L=60e-9 MR=1
MNM_SE0 sen SE VSS VPW nm1p2_svt_lp W=230e-9 L=60e-9 MR=1
MNM_sen net20 sen VSS VPW nm1p2_svt_lp W=470e-9 L=60e-9 MR=1
MNMR2 net59 SI VSS VPW nm1p2_svt_lp W=270e-9 L=60e-9 MR=1
MNM_D1 net61 D1 net20 VPW nm1p2_svt_lp W=470e-9 L=60e-9 MR=1
MNM_D0 net60 D0 net20 VPW nm1p2_svt_lp W=470e-9 L=60e-9 MR=1
MNM_SE2 net23 SE net59 VPW nm1p2_svt_lp W=470e-9 L=60e-9 MR=1
MNM_sn net23 sn net61 VPW nm1p2_svt_lp W=470e-9 L=60e-9 MR=1
MNM_S net23 S net60 VPW nm1p2_svt_lp W=470e-9 L=60e-9 MR=1
MNM3 net28 ckn net23 VPW nm1p2_svt_lp W=470e-9 L=60e-9 MR=1
MNM1 ckb ckn VSS VPW nm1p2_svt_lp W=230e-9 L=60e-9 MR=1
MNM0 ckn CK VSS VPW nm1p2_svt_lp W=230e-9 L=60e-9 MR=1
MPM11 Q net49 VDD VNW pm1p2_svt_lp W=590e-9 L=60e-9 MR=1
MPM10 net43 ckb net56 VNW pm1p2_svt_lp W=150e-9 L=60e-9 MR=1
MPM9 net56 net49 VDD VNW pm1p2_svt_lp W=150e-9 L=60e-9 MR=1
MPM8 net49 net43 VDD VNW pm1p2_svt_lp W=590e-9 L=60e-9 MR=1
MPM7 net43 ckn net38 VNW pm1p2_svt_lp W=590e-9 L=60e-9 MR=1
MPM6 net28 ckn net58 VNW pm1p2_svt_lp W=150e-9 L=60e-9 MR=1
MPM5 net58 net38 VDD VNW pm1p2_svt_lp W=150e-9 L=60e-9 MR=1
MPM4 net38 net28 VDD VNW pm1p2_svt_lp W=410e-9 L=60e-9 MR=1
MPM_S_D sn S VDD VNW pm1p2_svt_lp W=300e-9 L=60e-9 MR=1
MPM_SE0 sen SE VDD VNW pm1p2_svt_lp W=300e-9 L=60e-9 MR=1
MPM3 net28 ckb net23 VNW pm1p2_svt_lp W=410e-9 L=60e-9 MR=1
MPM_SE1 net21 SE VDD VNW pm1p2_svt_lp W=450e-9 L=60e-9 MR=1
MPMR2 net62 SI VDD VNW pm1p2_svt_lp W=590e-9 L=60e-9 MR=1
MPM_D1 net64 D1 net21 VNW pm1p2_svt_lp W=590e-9 L=60e-9 MR=1
MPM_D0 net63 D0 net21 VNW pm1p2_svt_lp W=590e-9 L=60e-9 MR=1
MPM_SE2 net23 sen net62 VNW pm1p2_svt_lp W=390e-9 L=60e-9 MR=1
MPM_S net23 S net64 VNW pm1p2_svt_lp W=390e-9 L=60e-9 MR=1
MPM_sn net23 sn net63 VNW pm1p2_svt_lp W=590e-9 L=60e-9 MR=1
MPM1 ckb ckn VDD VNW pm1p2_svt_lp W=300e-9 L=60e-9 MR=1
MPM0 ckn CK VDD VNW pm1p2_svt_lp W=300e-9 L=60e-9 MR=1
.ENDS
.SUBCKT SDFFXQX2_9TSVT CK D0 D1 Q S SE SI VDD VSS VNW VPW
MNM11 Q net49 VSS VPW nm1p2_svt_lp W=940e-9 L=60e-9 MR=1
MNM9 net55 net49 VSS VPW nm1p2_svt_lp W=150e-9 L=60e-9 MR=1
MNM10 net43 ckn net55 VPW nm1p2_svt_lp W=150e-9 L=60e-9 MR=1
MNM8 net49 net43 VSS VPW nm1p2_svt_lp W=470e-9 L=60e-9 MR=1
MNM7 net43 ckb net38 VPW nm1p2_svt_lp W=470e-9 L=60e-9 MR=1
MNM5 net57 net38 VSS VPW nm1p2_svt_lp W=150e-9 L=60e-9 MR=1
MNM6 net28 ckb net57 VPW nm1p2_svt_lp W=150e-9 L=60e-9 MR=1
MNM4 net38 net28 VSS VPW nm1p2_svt_lp W=470e-9 L=60e-9 MR=1
MNM_S_D sn S VSS VPW nm1p2_svt_lp W=230e-9 L=60e-9 MR=1
MNM_SE0 sen SE VSS VPW nm1p2_svt_lp W=230e-9 L=60e-9 MR=1
MNM_sen net20 sen VSS VPW nm1p2_svt_lp W=470e-9 L=60e-9 MR=1
MNMR2 net59 SI VSS VPW nm1p2_svt_lp W=270e-9 L=60e-9 MR=1
MNM_D1 net61 D1 net20 VPW nm1p2_svt_lp W=470e-9 L=60e-9 MR=1
MNM_D0 net60 D0 net20 VPW nm1p2_svt_lp W=470e-9 L=60e-9 MR=1
MNM_SE2 net23 SE net59 VPW nm1p2_svt_lp W=470e-9 L=60e-9 MR=1
MNM_sn net23 sn net61 VPW nm1p2_svt_lp W=470e-9 L=60e-9 MR=1
MNM_S net23 S net60 VPW nm1p2_svt_lp W=470e-9 L=60e-9 MR=1
MNM3 net28 ckn net23 VPW nm1p2_svt_lp W=470e-9 L=60e-9 MR=1
MNM1 ckb ckn VSS VPW nm1p2_svt_lp W=230e-9 L=60e-9 MR=1
MNM0 ckn CK VSS VPW nm1p2_svt_lp W=230e-9 L=60e-9 MR=1
MPM11 Q net49 VDD VNW pm1p2_svt_lp W=1.18e-6 L=60e-9 MR=1
MPM10 net43 ckb net56 VNW pm1p2_svt_lp W=150e-9 L=60e-9 MR=1
MPM9 net56 net49 VDD VNW pm1p2_svt_lp W=150e-9 L=60e-9 MR=1
MPM8 net49 net43 VDD VNW pm1p2_svt_lp W=590e-9 L=60e-9 MR=1
MPM7 net43 ckn net38 VNW pm1p2_svt_lp W=590e-9 L=60e-9 MR=1
MPM6 net28 ckn net58 VNW pm1p2_svt_lp W=150e-9 L=60e-9 MR=1
MPM5 net58 net38 VDD VNW pm1p2_svt_lp W=150e-9 L=60e-9 MR=1
MPM4 net38 net28 VDD VNW pm1p2_svt_lp W=410e-9 L=60e-9 MR=1
MPM_S_D sn S VDD VNW pm1p2_svt_lp W=300e-9 L=60e-9 MR=1
MPM_SE0 sen SE VDD VNW pm1p2_svt_lp W=300e-9 L=60e-9 MR=1
MPM3 net28 ckb net23 VNW pm1p2_svt_lp W=410e-9 L=60e-9 MR=1
MPM_SE1 net21 SE VDD VNW pm1p2_svt_lp W=450e-9 L=60e-9 MR=1
MPMR2 net62 SI VDD VNW pm1p2_svt_lp W=590e-9 L=60e-9 MR=1
MPM_D1 net64 D1 net21 VNW pm1p2_svt_lp W=590e-9 L=60e-9 MR=1
MPM_D0 net63 D0 net21 VNW pm1p2_svt_lp W=590e-9 L=60e-9 MR=1
MPM_SE2 net23 sen net62 VNW pm1p2_svt_lp W=390e-9 L=60e-9 MR=1
MPM_S net23 S net64 VNW pm1p2_svt_lp W=390e-9 L=60e-9 MR=1
MPM_sn net23 sn net63 VNW pm1p2_svt_lp W=590e-9 L=60e-9 MR=1
MPM1 ckb ckn VDD VNW pm1p2_svt_lp W=300e-9 L=60e-9 MR=1
MPM0 ckn CK VDD VNW pm1p2_svt_lp W=300e-9 L=60e-9 MR=1
.ENDS
.SUBCKT SDFFXQX4_9TSVT CK D0 D1 Q S SE SI VDD VSS VNW VPW
MNM11 Q net49 VSS VPW nm1p2_svt_lp W=1.88e-6 L=60e-9 MR=1
MNM9 net55 net49 VSS VPW nm1p2_svt_lp W=150e-9 L=60e-9 MR=1
MNM10 net43 ckn net55 VPW nm1p2_svt_lp W=150e-9 L=60e-9 MR=1
MNM8 net49 net43 VSS VPW nm1p2_svt_lp W=940e-9 L=60e-9 MR=1
MNM7 net43 ckb net38 VPW nm1p2_svt_lp W=470e-9 L=60e-9 MR=1
MNM5 net57 net38 VSS VPW nm1p2_svt_lp W=150e-9 L=60e-9 MR=1
MNM6 net28 ckb net57 VPW nm1p2_svt_lp W=150e-9 L=60e-9 MR=1
MNM4 net38 net28 VSS VPW nm1p2_svt_lp W=470e-9 L=60e-9 MR=1
MNM_S_D sn S VSS VPW nm1p2_svt_lp W=230e-9 L=60e-9 MR=1
MNM_SE0 sen SE VSS VPW nm1p2_svt_lp W=230e-9 L=60e-9 MR=1
MNM_sen net20 sen VSS VPW nm1p2_svt_lp W=470e-9 L=60e-9 MR=1
MNMR2 net59 SI VSS VPW nm1p2_svt_lp W=270e-9 L=60e-9 MR=1
MNM_D1 net61 D1 net20 VPW nm1p2_svt_lp W=470e-9 L=60e-9 MR=1
MNM_D0 net60 D0 net20 VPW nm1p2_svt_lp W=470e-9 L=60e-9 MR=1
MNM_SE2 net23 SE net59 VPW nm1p2_svt_lp W=470e-9 L=60e-9 MR=1
MNM_sn net23 sn net61 VPW nm1p2_svt_lp W=470e-9 L=60e-9 MR=1
MNM_S net23 S net60 VPW nm1p2_svt_lp W=470e-9 L=60e-9 MR=1
MNM3 net28 ckn net23 VPW nm1p2_svt_lp W=470e-9 L=60e-9 MR=1
MNM1 ckb ckn VSS VPW nm1p2_svt_lp W=470e-9 L=60e-9 MR=1
MNM0 ckn CK VSS VPW nm1p2_svt_lp W=470e-9 L=60e-9 MR=1
MPM11 Q net49 VDD VNW pm1p2_svt_lp W=2.36e-6 L=60e-9 MR=1
MPM10 net43 ckb net56 VNW pm1p2_svt_lp W=150e-9 L=60e-9 MR=1
MPM9 net56 net49 VDD VNW pm1p2_svt_lp W=150e-9 L=60e-9 MR=1
MPM8 net49 net43 VDD VNW pm1p2_svt_lp W=1.18e-6 L=60e-9 MR=1
MPM7 net43 ckn net38 VNW pm1p2_svt_lp W=590e-9 L=60e-9 MR=1
MPM6 net28 ckn net58 VNW pm1p2_svt_lp W=150e-9 L=60e-9 MR=1
MPM5 net58 net38 VDD VNW pm1p2_svt_lp W=150e-9 L=60e-9 MR=1
MPM4 net38 net28 VDD VNW pm1p2_svt_lp W=410e-9 L=60e-9 MR=1
MPM_S_D sn S VDD VNW pm1p2_svt_lp W=300e-9 L=60e-9 MR=1
MPM_SE0 sen SE VDD VNW pm1p2_svt_lp W=300e-9 L=60e-9 MR=1
MPM3 net28 ckb net23 VNW pm1p2_svt_lp W=410e-9 L=60e-9 MR=1
MPM_SE1 net21 SE VDD VNW pm1p2_svt_lp W=470e-9 L=60e-9 MR=1
MPMR2 net62 SI VDD VNW pm1p2_svt_lp W=590e-9 L=60e-9 MR=1
MPM_D1 net64 D1 net21 VNW pm1p2_svt_lp W=590e-9 L=60e-9 MR=1
MPM_D0 net63 D0 net21 VNW pm1p2_svt_lp W=590e-9 L=60e-9 MR=1
MPM_SE2 net23 sen net62 VNW pm1p2_svt_lp W=390e-9 L=60e-9 MR=1
MPM_S net23 S net64 VNW pm1p2_svt_lp W=390e-9 L=60e-9 MR=1
MPM_sn net23 sn net63 VNW pm1p2_svt_lp W=590e-9 L=60e-9 MR=1
MPM1 ckb ckn VDD VNW pm1p2_svt_lp W=590e-9 L=60e-9 MR=1
MPM0 ckn CK VDD VNW pm1p2_svt_lp W=390e-9 L=60e-9 MR=1
.ENDS
.SUBCKT SEDFFQX0P5_9TSVT CK D E Q SE SI VDD VSS VNW VPW
MNM11 Q net47 VSS VPW nm1p2_svt_lp W=230e-9 L=60e-9 MR=1
MNM9 net60 Q_BACK VSS VPW nm1p2_svt_lp W=150e-9 L=60e-9 MR=1
MNM10 net47 ckn net60 VPW nm1p2_svt_lp W=150e-9 L=60e-9 MR=1
MNM8 Q_BACK net47 VSS VPW nm1p2_svt_lp W=230e-9 L=60e-9 MR=1
MNM7 net47 ckb net44 VPW nm1p2_svt_lp W=230e-9 L=60e-9 MR=1
MNM5 net62 net44 VSS VPW nm1p2_svt_lp W=150e-9 L=60e-9 MR=1
MNM6 net35 ckb net62 VPW nm1p2_svt_lp W=150e-9 L=60e-9 MR=1
MNM4 net44 net35 VSS VPW nm1p2_svt_lp W=230e-9 L=60e-9 MR=1
MNM_SI0 SIN SI VSS VPW nm1p2_svt_lp W=230e-9 L=60e-9 MR=1
MNM_E0 EN E VSS VPW nm1p2_svt_lp W=230e-9 L=60e-9 MR=1
MNM_Q_BACK net64 Q_BACK VSS VPW nm1p2_svt_lp W=230e-9 L=60e-9 MR=1
MNM_E net65 D VSS VPW nm1p2_svt_lp W=230e-9 L=60e-9 MR=1
MNM_EN net22 EN net64 VPW nm1p2_svt_lp W=230e-9 L=60e-9 MR=1
MNM_D net22 E net65 VPW nm1p2_svt_lp W=230e-9 L=60e-9 MR=1
MNM_SE0 sen SE VSS VPW nm1p2_svt_lp W=230e-9 L=60e-9 MR=1
MNMR2 net68 SIN VSS VPW nm1p2_svt_lp W=230e-9 L=60e-9 MR=1
MNML2 net69 net22 VSS VPW nm1p2_svt_lp W=230e-9 L=60e-9 MR=1
MNM_SE2 net31 SE net68 VPW nm1p2_svt_lp W=230e-9 L=60e-9 MR=1
MNM_SE1 net31 sen net69 VPW nm1p2_svt_lp W=230e-9 L=60e-9 MR=1
MNM3 net35 ckn net31 VPW nm1p2_svt_lp W=230e-9 L=60e-9 MR=1
MNM1 ckb ckn VSS VPW nm1p2_svt_lp W=230e-9 L=60e-9 MR=1
MNM0 ckn CK VSS VPW nm1p2_svt_lp W=230e-9 L=60e-9 MR=1
MPM11 Q net47 VDD VNW pm1p2_svt_lp W=300e-9 L=60e-9 MR=1
MPM10 net47 ckb net61 VNW pm1p2_svt_lp W=150e-9 L=60e-9 MR=1
MPM9 net61 Q_BACK VDD VNW pm1p2_svt_lp W=150e-9 L=60e-9 MR=1
MPM8 Q_BACK net47 VDD VNW pm1p2_svt_lp W=300e-9 L=60e-9 MR=1
MPM7 net47 ckn net44 VNW pm1p2_svt_lp W=300e-9 L=60e-9 MR=1
MPM6 net35 ckn net63 VNW pm1p2_svt_lp W=150e-9 L=60e-9 MR=1
MPM5 net63 net44 VDD VNW pm1p2_svt_lp W=150e-9 L=60e-9 MR=1
MPM4 net44 net35 VDD VNW pm1p2_svt_lp W=300e-9 L=60e-9 MR=1
MPM_SI0 SIN SI VDD VNW pm1p2_svt_lp W=300e-9 L=60e-9 MR=1
MPM_E0 EN E VDD VNW pm1p2_svt_lp W=300e-9 L=60e-9 MR=1
MPM_Q_BACK net66 Q_BACK VDD VNW pm1p2_svt_lp W=300e-9 L=60e-9 MR=1
MPM_EN net67 D VDD VNW pm1p2_svt_lp W=300e-9 L=60e-9 MR=1
MPM_E net22 E net66 VNW pm1p2_svt_lp W=300e-9 L=60e-9 MR=1
MPM_D net22 EN net67 VNW pm1p2_svt_lp W=300e-9 L=60e-9 MR=1
MPM_SE0 sen SE VDD VNW pm1p2_svt_lp W=300e-9 L=60e-9 MR=1
MPM3 net35 ckb net31 VNW pm1p2_svt_lp W=300e-9 L=60e-9 MR=1
MPMR2 net70 SIN VDD VNW pm1p2_svt_lp W=300e-9 L=60e-9 MR=1
MPML2 net71 net22 VDD VNW pm1p2_svt_lp W=300e-9 L=60e-9 MR=1
MPM_SE2 net31 sen net70 VNW pm1p2_svt_lp W=300e-9 L=60e-9 MR=1
MPM_SE1 net31 SE net71 VNW pm1p2_svt_lp W=300e-9 L=60e-9 MR=1
MPM1 ckb ckn VDD VNW pm1p2_svt_lp W=300e-9 L=60e-9 MR=1
MPM0 ckn CK VDD VNW pm1p2_svt_lp W=300e-9 L=60e-9 MR=1
.ENDS
.SUBCKT SEDFFQX1_9TSVT CK D E Q SE SI VDD VSS VNW VPW
MNM11 Q net47 VSS VPW nm1p2_svt_lp W=470e-9 L=60e-9 MR=1
MNM9 net60 Q_BACK VSS VPW nm1p2_svt_lp W=150e-9 L=60e-9 MR=1
MNM10 net47 ckn net60 VPW nm1p2_svt_lp W=150e-9 L=60e-9 MR=1
MNM8 Q_BACK net47 VSS VPW nm1p2_svt_lp W=230e-9 L=60e-9 MR=1
MNM7 net47 ckb net44 VPW nm1p2_svt_lp W=470e-9 L=60e-9 MR=1
MNM5 net62 net44 VSS VPW nm1p2_svt_lp W=150e-9 L=60e-9 MR=1
MNM6 net35 ckb net62 VPW nm1p2_svt_lp W=150e-9 L=60e-9 MR=1
MNM4 net44 net35 VSS VPW nm1p2_svt_lp W=470e-9 L=60e-9 MR=1
MNM_SI0 SIN SI VSS VPW nm1p2_svt_lp W=230e-9 L=60e-9 MR=1
MNM_E0 EN E VSS VPW nm1p2_svt_lp W=230e-9 L=60e-9 MR=1
MNM_Q_BACK net64 Q_BACK VSS VPW nm1p2_svt_lp W=470e-9 L=60e-9 MR=1
MNM_E net65 D VSS VPW nm1p2_svt_lp W=470e-9 L=60e-9 MR=1
MNM_EN net22 EN net64 VPW nm1p2_svt_lp W=470e-9 L=60e-9 MR=1
MNM_D net22 E net65 VPW nm1p2_svt_lp W=470e-9 L=60e-9 MR=1
MNM_SE0 sen SE VSS VPW nm1p2_svt_lp W=230e-9 L=60e-9 MR=1
MNMR2 net68 SIN VSS VPW nm1p2_svt_lp W=470e-9 L=60e-9 MR=1
MNML2 net69 net22 VSS VPW nm1p2_svt_lp W=470e-9 L=60e-9 MR=1
MNM_SE2 net31 SE net68 VPW nm1p2_svt_lp W=470e-9 L=60e-9 MR=1
MNM_SE1 net31 sen net69 VPW nm1p2_svt_lp W=470e-9 L=60e-9 MR=1
MNM3 net35 ckn net31 VPW nm1p2_svt_lp W=470e-9 L=60e-9 MR=1
MNM1 ckb ckn VSS VPW nm1p2_svt_lp W=230e-9 L=60e-9 MR=1
MNM0 ckn CK VSS VPW nm1p2_svt_lp W=230e-9 L=60e-9 MR=1
MPM11 Q net47 VDD VNW pm1p2_svt_lp W=590e-9 L=60e-9 MR=1
MPM10 net47 ckb net61 VNW pm1p2_svt_lp W=150e-9 L=60e-9 MR=1
MPM9 net61 Q_BACK VDD VNW pm1p2_svt_lp W=150e-9 L=60e-9 MR=1
MPM8 Q_BACK net47 VDD VNW pm1p2_svt_lp W=300e-9 L=60e-9 MR=1
MPM7 net47 ckn net44 VNW pm1p2_svt_lp W=590e-9 L=60e-9 MR=1
MPM6 net35 ckn net63 VNW pm1p2_svt_lp W=150e-9 L=60e-9 MR=1
MPM5 net63 net44 VDD VNW pm1p2_svt_lp W=150e-9 L=60e-9 MR=1
MPM4 net44 net35 VDD VNW pm1p2_svt_lp W=410e-9 L=60e-9 MR=1
MPM_SI0 SIN SI VDD VNW pm1p2_svt_lp W=300e-9 L=60e-9 MR=1
MPM_E0 EN E VDD VNW pm1p2_svt_lp W=300e-9 L=60e-9 MR=1
MPM_Q_BACK net66 Q_BACK VDD VNW pm1p2_svt_lp W=590e-9 L=60e-9 MR=1
MPM_EN net67 D VDD VNW pm1p2_svt_lp W=590e-9 L=60e-9 MR=1
MPM_E net22 E net66 VNW pm1p2_svt_lp W=590e-9 L=60e-9 MR=1
MPM_D net22 EN net67 VNW pm1p2_svt_lp W=590e-9 L=60e-9 MR=1
MPM_SE0 sen SE VDD VNW pm1p2_svt_lp W=300e-9 L=60e-9 MR=1
MPM3 net35 ckb net31 VNW pm1p2_svt_lp W=410e-9 L=60e-9 MR=1
MPMR2 net70 SIN VDD VNW pm1p2_svt_lp W=590e-9 L=60e-9 MR=1
MPML2 net71 net22 VDD VNW pm1p2_svt_lp W=390e-9 L=60e-9 MR=1
MPM_SE2 net31 sen net70 VNW pm1p2_svt_lp W=590e-9 L=60e-9 MR=1
MPM_SE1 net31 SE net71 VNW pm1p2_svt_lp W=590e-9 L=60e-9 MR=1
MPM1 ckb ckn VDD VNW pm1p2_svt_lp W=300e-9 L=60e-9 MR=1
MPM0 ckn CK VDD VNW pm1p2_svt_lp W=300e-9 L=60e-9 MR=1
.ENDS
.SUBCKT SEDFFQX2_9TSVT CK D E Q SE SI VDD VSS VNW VPW
MNM11 Q net47 VSS VPW nm1p2_svt_lp W=940e-9 L=60e-9 MR=1
MNM9 net60 Q_BACK VSS VPW nm1p2_svt_lp W=150e-9 L=60e-9 MR=1
MNM10 net47 ckn net60 VPW nm1p2_svt_lp W=150e-9 L=60e-9 MR=1
MNM8 Q_BACK net47 VSS VPW nm1p2_svt_lp W=230e-9 L=60e-9 MR=1
MNM7 net47 ckb net44 VPW nm1p2_svt_lp W=470e-9 L=60e-9 MR=1
MNM5 net62 net44 VSS VPW nm1p2_svt_lp W=150e-9 L=60e-9 MR=1
MNM6 net35 ckb net62 VPW nm1p2_svt_lp W=150e-9 L=60e-9 MR=1
MNM4 net44 net35 VSS VPW nm1p2_svt_lp W=470e-9 L=60e-9 MR=1
MNM_SI0 SIN SI VSS VPW nm1p2_svt_lp W=230e-9 L=60e-9 MR=1
MNM_E0 EN E VSS VPW nm1p2_svt_lp W=230e-9 L=60e-9 MR=1
MNM_Q_BACK net64 Q_BACK VSS VPW nm1p2_svt_lp W=470e-9 L=60e-9 MR=1
MNM_E net65 D VSS VPW nm1p2_svt_lp W=470e-9 L=60e-9 MR=1
MNM_EN net22 EN net64 VPW nm1p2_svt_lp W=470e-9 L=60e-9 MR=1
MNM_D net22 E net65 VPW nm1p2_svt_lp W=470e-9 L=60e-9 MR=1
MNM_SE0 sen SE VSS VPW nm1p2_svt_lp W=230e-9 L=60e-9 MR=1
MNMR2 net68 SIN VSS VPW nm1p2_svt_lp W=470e-9 L=60e-9 MR=1
MNML2 net69 net22 VSS VPW nm1p2_svt_lp W=470e-9 L=60e-9 MR=1
MNM_SE2 net31 SE net68 VPW nm1p2_svt_lp W=470e-9 L=60e-9 MR=1
MNM_SE1 net31 sen net69 VPW nm1p2_svt_lp W=470e-9 L=60e-9 MR=1
MNM3 net35 ckn net31 VPW nm1p2_svt_lp W=470e-9 L=60e-9 MR=1
MNM1 ckb ckn VSS VPW nm1p2_svt_lp W=230e-9 L=60e-9 MR=1
MNM0 ckn CK VSS VPW nm1p2_svt_lp W=230e-9 L=60e-9 MR=1
MPM11 Q net47 VDD VNW pm1p2_svt_lp W=1.18e-6 L=60e-9 MR=1
MPM10 net47 ckb net61 VNW pm1p2_svt_lp W=150e-9 L=60e-9 MR=1
MPM9 net61 Q_BACK VDD VNW pm1p2_svt_lp W=150e-9 L=60e-9 MR=1
MPM8 Q_BACK net47 VDD VNW pm1p2_svt_lp W=300e-9 L=60e-9 MR=1
MPM7 net47 ckn net44 VNW pm1p2_svt_lp W=590e-9 L=60e-9 MR=1
MPM6 net35 ckn net63 VNW pm1p2_svt_lp W=150e-9 L=60e-9 MR=1
MPM5 net63 net44 VDD VNW pm1p2_svt_lp W=150e-9 L=60e-9 MR=1
MPM4 net44 net35 VDD VNW pm1p2_svt_lp W=410e-9 L=60e-9 MR=1
MPM_SI0 SIN SI VDD VNW pm1p2_svt_lp W=300e-9 L=60e-9 MR=1
MPM_E0 EN E VDD VNW pm1p2_svt_lp W=300e-9 L=60e-9 MR=1
MPM_Q_BACK net66 Q_BACK VDD VNW pm1p2_svt_lp W=590e-9 L=60e-9 MR=1
MPM_EN net67 D VDD VNW pm1p2_svt_lp W=590e-9 L=60e-9 MR=1
MPM_E net22 E net66 VNW pm1p2_svt_lp W=590e-9 L=60e-9 MR=1
MPM_D net22 EN net67 VNW pm1p2_svt_lp W=590e-9 L=60e-9 MR=1
MPM_SE0 sen SE VDD VNW pm1p2_svt_lp W=300e-9 L=60e-9 MR=1
MPM3 net35 ckb net31 VNW pm1p2_svt_lp W=410e-9 L=60e-9 MR=1
MPMR2 net70 SIN VDD VNW pm1p2_svt_lp W=590e-9 L=60e-9 MR=1
MPML2 net71 net22 VDD VNW pm1p2_svt_lp W=390e-9 L=60e-9 MR=1
MPM_SE2 net31 sen net70 VNW pm1p2_svt_lp W=590e-9 L=60e-9 MR=1
MPM_SE1 net31 SE net71 VNW pm1p2_svt_lp W=590e-9 L=60e-9 MR=1
MPM1 ckb ckn VDD VNW pm1p2_svt_lp W=300e-9 L=60e-9 MR=1
MPM0 ckn CK VDD VNW pm1p2_svt_lp W=300e-9 L=60e-9 MR=1
.ENDS
.SUBCKT SEDFFQX4_9TSVT CK D E Q SE SI VDD VSS VNW VPW
MNM11 Q net47 VSS VPW nm1p2_svt_lp W=1.88e-6 L=60e-9 MR=1
MNM9 net60 Q_BACK VSS VPW nm1p2_svt_lp W=150e-9 L=60e-9 MR=1
MNM10 net47 ckn net60 VPW nm1p2_svt_lp W=150e-9 L=60e-9 MR=1
MNM8 Q_BACK net47 VSS VPW nm1p2_svt_lp W=230e-9 L=60e-9 MR=1
MNM7 net47 ckb net44 VPW nm1p2_svt_lp W=400e-9 L=60e-9 MR=1
MNM5 net62 net44 VSS VPW nm1p2_svt_lp W=150e-9 L=60e-9 MR=1
MNM6 net35 ckb net62 VPW nm1p2_svt_lp W=150e-9 L=60e-9 MR=1
MNM4 net44 net35 VSS VPW nm1p2_svt_lp W=940e-9 L=60e-9 MR=1
MNM_SI0 SIN SI VSS VPW nm1p2_svt_lp W=230e-9 L=60e-9 MR=1
MNM_E0 EN E VSS VPW nm1p2_svt_lp W=230e-9 L=60e-9 MR=1
MNM_Q_BACK net64 Q_BACK VSS VPW nm1p2_svt_lp W=470e-9 L=60e-9 MR=1
MNM_E net65 D VSS VPW nm1p2_svt_lp W=470e-9 L=60e-9 MR=1
MNM_EN net22 EN net64 VPW nm1p2_svt_lp W=470e-9 L=60e-9 MR=1
MNM_D net22 E net65 VPW nm1p2_svt_lp W=470e-9 L=60e-9 MR=1
MNM_SE0 sen SE VSS VPW nm1p2_svt_lp W=230e-9 L=60e-9 MR=1
MNMR2 net68 SIN VSS VPW nm1p2_svt_lp W=470e-9 L=60e-9 MR=1
MNML2 net69 net22 VSS VPW nm1p2_svt_lp W=470e-9 L=60e-9 MR=1
MNM_SE2 net31 SE net68 VPW nm1p2_svt_lp W=470e-9 L=60e-9 MR=1
MNM_SE1 net31 sen net69 VPW nm1p2_svt_lp W=470e-9 L=60e-9 MR=1
MNM3 net35 ckn net31 VPW nm1p2_svt_lp W=470e-9 L=60e-9 MR=1
MNM1 ckb ckn VSS VPW nm1p2_svt_lp W=470e-9 L=60e-9 MR=1
MNM0 ckn CK VSS VPW nm1p2_svt_lp W=470e-9 L=60e-9 MR=1
MPM11 Q net47 VDD VNW pm1p2_svt_lp W=2.36e-6 L=60e-9 MR=1
MPM10 net47 ckb net61 VNW pm1p2_svt_lp W=150e-9 L=60e-9 MR=1
MPM9 net61 Q_BACK VDD VNW pm1p2_svt_lp W=150e-9 L=60e-9 MR=1
MPM8 Q_BACK net47 VDD VNW pm1p2_svt_lp W=300e-9 L=60e-9 MR=1
MPM7 net47 ckn net44 VNW pm1p2_svt_lp W=590e-9 L=60e-9 MR=1
MPM6 net35 ckn net63 VNW pm1p2_svt_lp W=150e-9 L=60e-9 MR=1
MPM5 net63 net44 VDD VNW pm1p2_svt_lp W=150e-9 L=60e-9 MR=1
MPM4 net44 net35 VDD VNW pm1p2_svt_lp W=0.78e-6 L=60e-9 MR=1
MPM_SI0 SIN SI VDD VNW pm1p2_svt_lp W=300e-9 L=60e-9 MR=1
MPM_E0 EN E VDD VNW pm1p2_svt_lp W=300e-9 L=60e-9 MR=1
MPM_Q_BACK net66 Q_BACK VDD VNW pm1p2_svt_lp W=590e-9 L=60e-9 MR=1
MPM_EN net67 D VDD VNW pm1p2_svt_lp W=590e-9 L=60e-9 MR=1
MPM_E net22 E net66 VNW pm1p2_svt_lp W=590e-9 L=60e-9 MR=1
MPM_D net22 EN net67 VNW pm1p2_svt_lp W=590e-9 L=60e-9 MR=1
MPM_SE0 sen SE VDD VNW pm1p2_svt_lp W=300e-9 L=60e-9 MR=1
MPM3 net35 ckb net31 VNW pm1p2_svt_lp W=376e-9 L=60e-9 MR=1
MPMR2 net70 SIN VDD VNW pm1p2_svt_lp W=590e-9 L=60e-9 MR=1
MPML2 net71 net22 VDD VNW pm1p2_svt_lp W=390e-9 L=60e-9 MR=1
MPM_SE2 net31 sen net70 VNW pm1p2_svt_lp W=590e-9 L=60e-9 MR=1
MPM_SE1 net31 SE net71 VNW pm1p2_svt_lp W=590e-9 L=60e-9 MR=1
MPM1 ckb ckn VDD VNW pm1p2_svt_lp W=590e-9 L=60e-9 MR=1
MPM0 ckn CK VDD VNW pm1p2_svt_lp W=590e-9 L=60e-9 MR=1
.ENDS
.SUBCKT TAPVNPWX1_9TSVT VDD   VSS VNW VPW
.ENDS
.SUBCKT TAPX1_9TSVT VDD VSS VNW VPW
.ENDS
.SUBCKT TBUFX0P5_9TSVT A OE VDD VSS Y VNW VPW
MNM5 Y net18 VSS VPW nm1p2_svt_lp W=230e-9 L=60e-9 MR=1
MNM4 net18 A VSS VPW nm1p2_svt_lp W=230e-9 L=60e-9 MR=1
MNM3 net18 oen VSS VPW nm1p2_svt_lp W=230e-9 L=60e-9 MR=1
MNM2 oen OE VSS VPW nm1p2_svt_lp W=230e-9 L=60e-9 MR=1
MNM1 net30 A VSS VPW nm1p2_svt_lp W=230e-9 L=60e-9 MR=1
MNM0 net20 OE net30 VPW nm1p2_svt_lp W=230e-9 L=60e-9 MR=1
MPM5 Y net20 VDD VNW pm1p2_svt_lp W=300e-9 L=60e-9 MR=1
MPM4 net29 A VDD VNW pm1p2_svt_lp W=300e-9 L=60e-9 MR=1
MPM3 net18 oen net29 VNW pm1p2_svt_lp W=300e-9 L=60e-9 MR=1
MPM2 oen OE VDD VNW pm1p2_svt_lp W=300e-9 L=60e-9 MR=1
MPM1 net20 A VDD VNW pm1p2_svt_lp W=300e-9 L=60e-9 MR=1
MPM0 net20 OE VDD VNW pm1p2_svt_lp W=300e-9 L=60e-9 MR=1
.ENDS
.SUBCKT TBUFX1_9TSVT A OE VDD VSS Y VNW VPW
MNM5 Y net18 VSS VPW nm1p2_svt_lp W=470e-9 L=60e-9 MR=1
MNM4 net18 A VSS VPW nm1p2_svt_lp W=230e-9 L=60e-9 MR=1
MNM3 net18 oen VSS VPW nm1p2_svt_lp W=230e-9 L=60e-9 MR=1
MNM2 oen OE VSS VPW nm1p2_svt_lp W=230e-9 L=60e-9 MR=1
MNM1 net30 A VSS VPW nm1p2_svt_lp W=230e-9 L=60e-9 MR=1
MNM0 net20 OE net30 VPW nm1p2_svt_lp W=230e-9 L=60e-9 MR=1
MPM5 Y net20 VDD VNW pm1p2_svt_lp W=590e-9 L=60e-9 MR=1
MPM4 net29 A VDD VNW pm1p2_svt_lp W=300e-9 L=60e-9 MR=1
MPM3 net18 oen net29 VNW pm1p2_svt_lp W=300e-9 L=60e-9 MR=1
MPM2 oen OE VDD VNW pm1p2_svt_lp W=300e-9 L=60e-9 MR=1
MPM1 net20 A VDD VNW pm1p2_svt_lp W=300e-9 L=60e-9 MR=1
MPM0 net20 OE VDD VNW pm1p2_svt_lp W=300e-9 L=60e-9 MR=1
.ENDS
.SUBCKT TBUFX2_9TSVT A OE VDD VSS Y VNW VPW
MNM5 Y net18 VSS VPW nm1p2_svt_lp W=940e-9 L=60e-9 MR=1
MNM4 net18 A VSS VPW nm1p2_svt_lp W=470e-9 L=60e-9 MR=1
MNM3 net18 oen VSS VPW nm1p2_svt_lp W=470e-9 L=60e-9 MR=1
MNM2 oen OE VSS VPW nm1p2_svt_lp W=470e-9 L=60e-9 MR=1
MNM1 net30 A VSS VPW nm1p2_svt_lp W=470e-9 L=60e-9 MR=1
MNM0 net20 OE net30 VPW nm1p2_svt_lp W=470e-9 L=60e-9 MR=1
MPM5 Y net20 VDD VNW pm1p2_svt_lp W=1.18e-6 L=60e-9 MR=1
MPM4 net29 A VDD VNW pm1p2_svt_lp W=590e-9 L=60e-9 MR=1
MPM3 net18 oen net29 VNW pm1p2_svt_lp W=590e-9 L=60e-9 MR=1
MPM2 oen OE VDD VNW pm1p2_svt_lp W=590e-9 L=60e-9 MR=1
MPM1 net20 A VDD VNW pm1p2_svt_lp W=590e-9 L=60e-9 MR=1
MPM0 net20 OE VDD VNW pm1p2_svt_lp W=590e-9 L=60e-9 MR=1
.ENDS
.SUBCKT TBUFX3_9TSVT A OE VDD VSS Y VNW VPW
MNM5 Y net18 VSS VPW nm1p2_svt_lp W=1.41e-6 L=60e-9 MR=1
MNM4 net18 A VSS VPW nm1p2_svt_lp W=470e-9 L=60e-9 MR=1
MNM3 net18 oen VSS VPW nm1p2_svt_lp W=470e-9 L=60e-9 MR=1
MNM2 oen OE VSS VPW nm1p2_svt_lp W=470e-9 L=60e-9 MR=1
MNM1 net30 A VSS VPW nm1p2_svt_lp W=470e-9 L=60e-9 MR=1
MNM0 net20 OE net30 VPW nm1p2_svt_lp W=470e-9 L=60e-9 MR=1
MPM5 Y net20 VDD VNW pm1p2_svt_lp W=1.77e-6 L=60e-9 MR=1
MPM4 net29 A VDD VNW pm1p2_svt_lp W=590e-9 L=60e-9 MR=1
MPM3 net18 oen net29 VNW pm1p2_svt_lp W=590e-9 L=60e-9 MR=1
MPM2 oen OE VDD VNW pm1p2_svt_lp W=590e-9 L=60e-9 MR=1
MPM1 net20 A VDD VNW pm1p2_svt_lp W=590e-9 L=60e-9 MR=1
MPM0 net20 OE VDD VNW pm1p2_svt_lp W=590e-9 L=60e-9 MR=1
.ENDS
.SUBCKT TBUFX4_9TSVT A OE VDD VSS Y VNW VPW
MNM5 Y net18 VSS VPW nm1p2_svt_lp W=1.88e-6 L=60e-9 MR=1
MNM4 net18 A VSS VPW nm1p2_svt_lp W=470e-9 L=60e-9 MR=1
MNM3 net18 oen VSS VPW nm1p2_svt_lp W=470e-9 L=60e-9 MR=1
MNM2 oen OE VSS VPW nm1p2_svt_lp W=470e-9 L=60e-9 MR=1
MNM1 net30 A VSS VPW nm1p2_svt_lp W=470e-9 L=60e-9 MR=1
MNM0 net20 OE net30 VPW nm1p2_svt_lp W=470e-9 L=60e-9 MR=1
MPM5 Y net20 VDD VNW pm1p2_svt_lp W=2.36e-6 L=60e-9 MR=1
MPM4 net29 A VDD VNW pm1p2_svt_lp W=590e-9 L=60e-9 MR=1
MPM3 net18 oen net29 VNW pm1p2_svt_lp W=590e-9 L=60e-9 MR=1
MPM2 oen OE VDD VNW pm1p2_svt_lp W=590e-9 L=60e-9 MR=1
MPM1 net20 A VDD VNW pm1p2_svt_lp W=590e-9 L=60e-9 MR=1
MPM0 net20 OE VDD VNW pm1p2_svt_lp W=590e-9 L=60e-9 MR=1
.ENDS
.SUBCKT TBUFX5_9TSVT A OE VDD VSS Y VNW VPW
MNM5 Y net18 VSS VPW nm1p2_svt_lp W=2.35e-6 L=60e-9 MR=1
MNM4 net18 A VSS VPW nm1p2_svt_lp W=470e-9 L=60e-9 MR=1
MNM3 net18 oen VSS VPW nm1p2_svt_lp W=470e-9 L=60e-9 MR=1
MNM2 oen OE VSS VPW nm1p2_svt_lp W=470e-9 L=60e-9 MR=1
MNM1 net30 A VSS VPW nm1p2_svt_lp W=470e-9 L=60e-9 MR=1
MNM0 net20 OE net30 VPW nm1p2_svt_lp W=470e-9 L=60e-9 MR=1
MPM5 Y net20 VDD VNW pm1p2_svt_lp W=2.95e-6 L=60e-9 MR=1
MPM4 net29 A VDD VNW pm1p2_svt_lp W=590e-9 L=60e-9 MR=1
MPM3 net18 oen net29 VNW pm1p2_svt_lp W=590e-9 L=60e-9 MR=1
MPM2 oen OE VDD VNW pm1p2_svt_lp W=590e-9 L=60e-9 MR=1
MPM1 net20 A VDD VNW pm1p2_svt_lp W=590e-9 L=60e-9 MR=1
MPM0 net20 OE VDD VNW pm1p2_svt_lp W=590e-9 L=60e-9 MR=1
.ENDS
.SUBCKT TBUFX6_9TSVT A OE VDD VSS Y VNW VPW
MNM5 Y net18 VSS VPW nm1p2_svt_lp W=2.82e-6 L=60e-9 MR=1
MNM4 net18 A VSS VPW nm1p2_svt_lp W=940e-9 L=60e-9 MR=1
MNM3 net18 oen VSS VPW nm1p2_svt_lp W=940e-9 L=60e-9 MR=1
MNM2 oen OE VSS VPW nm1p2_svt_lp W=470e-9 L=60e-9 MR=1
MNM1 net30 A VSS VPW nm1p2_svt_lp W=940e-9 L=60e-9 MR=1
MNM0 net20 OE net30 VPW nm1p2_svt_lp W=940e-9 L=60e-9 MR=1
MPM5 Y net20 VDD VNW pm1p2_svt_lp W=3.54e-6 L=60e-9 MR=1
MPM4 net29 A VDD VNW pm1p2_svt_lp W=950e-9 L=60e-9 MR=1
MPM3 net18 oen net29 VNW pm1p2_svt_lp W=1.18e-6 L=60e-9 MR=1
MPM2 oen OE VDD VNW pm1p2_svt_lp W=590e-9 L=60e-9 MR=1
MPM1 net20 A VDD VNW pm1p2_svt_lp W=1.18e-6 L=60e-9 MR=1
MPM0 net20 OE VDD VNW pm1p2_svt_lp W=1.18e-6 L=60e-9 MR=1
.ENDS
.SUBCKT TBUFX8_9TSVT A OE VDD VSS Y VNW VPW
MNM5 Y net18 VSS VPW nm1p2_svt_lp W=3.76e-6 L=60e-9 MR=1
MNM4 net18 A VSS VPW nm1p2_svt_lp W=940e-9 L=60e-9 MR=1
MNM3 net18 oen VSS VPW nm1p2_svt_lp W=940e-9 L=60e-9 MR=1
MNM2 oen OE VSS VPW nm1p2_svt_lp W=470e-9 L=60e-9 MR=1
MNM1 net30 A VSS VPW nm1p2_svt_lp W=940e-9 L=60e-9 MR=1
MNM0 net20 OE net30 VPW nm1p2_svt_lp W=940e-9 L=60e-9 MR=1
MPM5 Y net20 VDD VNW pm1p2_svt_lp W=4.72e-6 L=60e-9 MR=1
MPM4 net29 A VDD VNW pm1p2_svt_lp W=950e-9 L=60e-9 MR=1
MPM3 net18 oen net29 VNW pm1p2_svt_lp W=1.18e-6 L=60e-9 MR=1
MPM2 oen OE VDD VNW pm1p2_svt_lp W=590e-9 L=60e-9 MR=1
MPM1 net20 A VDD VNW pm1p2_svt_lp W=1.18e-6 L=60e-9 MR=1
MPM0 net20 OE VDD VNW pm1p2_svt_lp W=1.18e-6 L=60e-9 MR=1
.ENDS
.SUBCKT TIEHIX1_9TSVT VDD VSS Y VNW VPW
MNM0 net5 net5 VSS VPW nm1p2_svt_lp W=470e-9 L=60e-9 MR=1
MPM0 Y net5 VDD VNW pm1p2_svt_lp W=590e-9 L=60e-9 MR=1
.ENDS
.SUBCKT TIELOX1_9TSVT VDD VSS Y VNW VPW
MNM0 Y net5 VSS VPW nm1p2_svt_lp W=470e-9 L=60e-9 MR=1
MPM0 net5 net5 VDD VNW pm1p2_svt_lp W=590e-9 L=60e-9 MR=1
.ENDS
.SUBCKT XNOR2X0P5_9TSVT A B VDD VSS Y VNW VPW
MNM5 Y net16 VSS VPW nm1p2_svt_lp W=230e-9 L=60e-9 MR=1
MNM4 net16 AN BB VPW nm1p2_svt_lp W=230e-9 L=60e-9 MR=1
MNM3 net16 A BN VPW nm1p2_svt_lp W=230e-9 L=60e-9 MR=1
MNM2 BB BN VSS VPW nm1p2_svt_lp W=230e-9 L=60e-9 MR=1
MNM1 BN B VSS VPW nm1p2_svt_lp W=230e-9 L=60e-9 MR=1
MNM0 AN A VSS VPW nm1p2_svt_lp W=230e-9 L=60e-9 MR=1
MPM5 Y net16 VDD VNW pm1p2_svt_lp W=300e-9 L=60e-9 MR=1
MPM4 net16 A BB VNW pm1p2_svt_lp W=300e-9 L=60e-9 MR=1
MPM3 net16 AN BN VNW pm1p2_svt_lp W=300e-9 L=60e-9 MR=1
MPM2 BB BN VDD VNW pm1p2_svt_lp W=300e-9 L=60e-9 MR=1
MPM1 BN B VDD VNW pm1p2_svt_lp W=300e-9 L=60e-9 MR=1
MPM0 AN A VDD VNW pm1p2_svt_lp W=300e-9 L=60e-9 MR=1
.ENDS
.SUBCKT XNOR2X1_9TSVT A B VDD VSS Y VNW VPW
MNM5 Y net16 VSS VPW nm1p2_svt_lp W=470e-9 L=60e-9 MR=1
MNM4 net16 AN BB VPW nm1p2_svt_lp W=230e-9 L=60e-9 MR=1
MNM3 net16 A BN VPW nm1p2_svt_lp W=230e-9 L=60e-9 MR=1
MNM2 BB BN VSS VPW nm1p2_svt_lp W=230e-9 L=60e-9 MR=1
MNM1 BN B VSS VPW nm1p2_svt_lp W=230e-9 L=60e-9 MR=1
MNM0 AN A VSS VPW nm1p2_svt_lp W=230e-9 L=60e-9 MR=1
MPM5 Y net16 VDD VNW pm1p2_svt_lp W=590e-9 L=60e-9 MR=1
MPM4 net16 A BB VNW pm1p2_svt_lp W=300e-9 L=60e-9 MR=1
MPM3 net16 AN BN VNW pm1p2_svt_lp W=300e-9 L=60e-9 MR=1
MPM2 BB BN VDD VNW pm1p2_svt_lp W=300e-9 L=60e-9 MR=1
MPM1 BN B VDD VNW pm1p2_svt_lp W=300e-9 L=60e-9 MR=1
MPM0 AN A VDD VNW pm1p2_svt_lp W=300e-9 L=60e-9 MR=1
.ENDS
.SUBCKT XNOR2X2_9TSVT A B VDD VSS Y VNW VPW
MNM5 Y net16 VSS VPW nm1p2_svt_lp W=940e-9 L=60e-9 MR=1
MNM4 net16 AN BB VPW nm1p2_svt_lp W=470e-9 L=60e-9 MR=1
MNM3 net16 A BN VPW nm1p2_svt_lp W=470e-9 L=60e-9 MR=1
MNM2 BB BN VSS VPW nm1p2_svt_lp W=470e-9 L=60e-9 MR=1
MNM1 BN B VSS VPW nm1p2_svt_lp W=470e-9 L=60e-9 MR=1
MNM0 AN A VSS VPW nm1p2_svt_lp W=180e-9 L=60e-9 MR=1
MPM5 Y net16 VDD VNW pm1p2_svt_lp W=1.18e-6 L=60e-9 MR=1
MPM4 net16 A BB VNW pm1p2_svt_lp W=590e-9 L=60e-9 MR=1
MPM3 net16 AN BN VNW pm1p2_svt_lp W=590e-9 L=60e-9 MR=1
MPM2 BB BN VDD VNW pm1p2_svt_lp W=590e-9 L=60e-9 MR=1
MPM1 BN B VDD VNW pm1p2_svt_lp W=590e-9 L=60e-9 MR=1
MPM0 AN A VDD VNW pm1p2_svt_lp W=300e-9 L=60e-9 MR=1
.ENDS
.SUBCKT XNOR2X4_9TSVT A B VDD VSS Y VNW VPW
MNM5 Y net16 VSS VPW nm1p2_svt_lp W=1.88e-6 L=60e-9 MR=1
MNM4 net16 AN BB VPW nm1p2_svt_lp W=470e-9 L=60e-9 MR=1
MNM3 net16 A BN VPW nm1p2_svt_lp W=470e-9 L=60e-9 MR=1
MNM2 BB BN VSS VPW nm1p2_svt_lp W=940n L=60n MR=1
MNM1 BN B VSS VPW nm1p2_svt_lp W=940e-9 L=60e-9 MR=1
MNM0 AN A VSS VPW nm1p2_svt_lp W=230n L=60n MR=1
MPM5 Y net16 VDD VNW pm1p2_svt_lp W=2.36e-6 L=60e-9 MR=1
MPM4 net16 A BB VNW pm1p2_svt_lp W=590e-9 L=60e-9 MR=1
MPM3 net16 AN BN VNW pm1p2_svt_lp W=590e-9 L=60e-9 MR=1
MPM2 BB BN VDD VNW pm1p2_svt_lp W=1.18u L=60n MR=1
MPM1 BN B VDD VNW pm1p2_svt_lp W=1.18e-6 L=60e-9 MR=1
MPM0 AN A VDD VNW pm1p2_svt_lp W=300n L=60n MR=1
.ENDS
.SUBCKT XNOR2X8_9TSVT A B VDD VSS Y VNW VPW
MNM5 Y net16 VSS VPW nm1p2_svt_lp W=3.76e-6 L=60e-9 MR=1
MNM4 net16 AN BB VPW nm1p2_svt_lp W=470e-9 L=60e-9 MR=1
MNM3 net16 A BN VPW nm1p2_svt_lp W=470e-9 L=60e-9 MR=1
MNM2 BB BN VSS VPW nm1p2_svt_lp W=1.41u L=60n MR=1
MNM1 BN B VSS VPW nm1p2_svt_lp W=1.41e-6 L=60e-9 MR=1
MNM0 AN A VSS VPW nm1p2_svt_lp W=230n L=60n MR=1
MPM5 Y net16 VDD VNW pm1p2_svt_lp W=4.72e-6 L=60e-9 MR=1
MPM4 net16 A BB VNW pm1p2_svt_lp W=590e-9 L=60e-9 MR=1
MPM3 net16 AN BN VNW pm1p2_svt_lp W=590e-9 L=60e-9 MR=1
MPM2 BB BN VDD VNW pm1p2_svt_lp W=1.77u L=60n MR=1
MPM1 BN B VDD VNW pm1p2_svt_lp W=1.77e-6 L=60e-9 MR=1
MPM0 AN A VDD VNW pm1p2_svt_lp W=300n L=60n MR=1
.ENDS
.SUBCKT XNOR3X0P5_9TSVT A B C VDD VSS Y VNW VPW
MNM11 Y net33 VSS VPW nm1p2_svt_lp W=230e-9 L=60e-9 MR=1
MNM10 net33 outn CC VPW nm1p2_svt_lp W=230e-9 L=60e-9 MR=1
MNM9 net33 out CN VPW nm1p2_svt_lp W=230e-9 L=60e-9 MR=1
MNM8 CC CN VSS VPW nm1p2_svt_lp W=230e-9 L=60e-9 MR=1
MNM7 CN C VSS VPW nm1p2_svt_lp W=230e-9 L=60e-9 MR=1
MNM5 outn out VSS VPW nm1p2_svt_lp W=230e-9 L=60e-9 MR=1
MNM4 out AN BB VPW nm1p2_svt_lp W=230e-9 L=60e-9 MR=1
MNM3 out A BN VPW nm1p2_svt_lp W=230e-9 L=60e-9 MR=1
MNM2 BB BN VSS VPW nm1p2_svt_lp W=230e-9 L=60e-9 MR=1
MNM1 BN B VSS VPW nm1p2_svt_lp W=230e-9 L=60e-9 MR=1
MNM0 AN A VSS VPW nm1p2_svt_lp W=230e-9 L=60e-9 MR=1
MPM11 Y net33 VDD VNW pm1p2_svt_lp W=300e-9 L=60e-9 MR=1
MPM10 net33 out CC VNW pm1p2_svt_lp W=300e-9 L=60e-9 MR=1
MPM9 net33 outn CN VNW pm1p2_svt_lp W=300e-9 L=60e-9 MR=1
MPM8 CC CN VDD VNW pm1p2_svt_lp W=300e-9 L=60e-9 MR=1
MPM7 CN C VDD VNW pm1p2_svt_lp W=300e-9 L=60e-9 MR=1
MPM5 outn out VDD VNW pm1p2_svt_lp W=300e-9 L=60e-9 MR=1
MPM4 out A BB VNW pm1p2_svt_lp W=300e-9 L=60e-9 MR=1
MPM3 out AN BN VNW pm1p2_svt_lp W=300e-9 L=60e-9 MR=1
MPM2 BB BN VDD VNW pm1p2_svt_lp W=300e-9 L=60e-9 MR=1
MPM1 BN B VDD VNW pm1p2_svt_lp W=300e-9 L=60e-9 MR=1
MPM0 AN A VDD VNW pm1p2_svt_lp W=300e-9 L=60e-9 MR=1
.ENDS
.SUBCKT XNOR3X1_9TSVT A B C VDD VSS Y VNW VPW
MNM11 Y net33 VSS VPW nm1p2_svt_lp W=470e-9 L=60e-9 MR=1
MNM10 net33 outn CC VPW nm1p2_svt_lp W=230e-9 L=60e-9 MR=1
MNM9 net33 out CN VPW nm1p2_svt_lp W=230e-9 L=60e-9 MR=1
MNM8 CC CN VSS VPW nm1p2_svt_lp W=230e-9 L=60e-9 MR=1
MNM7 CN C VSS VPW nm1p2_svt_lp W=230e-9 L=60e-9 MR=1
MNM5 outn out VSS VPW nm1p2_svt_lp W=230e-9 L=60e-9 MR=1
MNM4 out AN BB VPW nm1p2_svt_lp W=230e-9 L=60e-9 MR=1
MNM3 out A BN VPW nm1p2_svt_lp W=230e-9 L=60e-9 MR=1
MNM2 BB BN VSS VPW nm1p2_svt_lp W=230e-9 L=60e-9 MR=1
MNM1 BN B VSS VPW nm1p2_svt_lp W=230e-9 L=60e-9 MR=1
MNM0 AN A VSS VPW nm1p2_svt_lp W=230e-9 L=60e-9 MR=1
MPM11 Y net33 VDD VNW pm1p2_svt_lp W=590e-9 L=60e-9 MR=1
MPM10 net33 out CC VNW pm1p2_svt_lp W=300e-9 L=60e-9 MR=1
MPM9 net33 outn CN VNW pm1p2_svt_lp W=300e-9 L=60e-9 MR=1
MPM8 CC CN VDD VNW pm1p2_svt_lp W=300e-9 L=60e-9 MR=1
MPM7 CN C VDD VNW pm1p2_svt_lp W=300e-9 L=60e-9 MR=1
MPM5 outn out VDD VNW pm1p2_svt_lp W=300e-9 L=60e-9 MR=1
MPM4 out A BB VNW pm1p2_svt_lp W=300e-9 L=60e-9 MR=1
MPM3 out AN BN VNW pm1p2_svt_lp W=300e-9 L=60e-9 MR=1
MPM2 BB BN VDD VNW pm1p2_svt_lp W=300e-9 L=60e-9 MR=1
MPM1 BN B VDD VNW pm1p2_svt_lp W=300e-9 L=60e-9 MR=1
MPM0 AN A VDD VNW pm1p2_svt_lp W=300e-9 L=60e-9 MR=1
.ENDS
.SUBCKT XNOR3X2_9TSVT A B C VDD VSS Y VNW VPW
MNM11 Y net33 VSS VPW nm1p2_svt_lp W=940e-9 L=60e-9 MR=1
MNM10 net33 outn CC VPW nm1p2_svt_lp W=470e-9 L=60e-9 MR=1
MNM9 net33 out CN VPW nm1p2_svt_lp W=470e-9 L=60e-9 MR=1
MNM8 CC CN VSS VPW nm1p2_svt_lp W=470e-9 L=60e-9 MR=1
MNM7 CN C VSS VPW nm1p2_svt_lp W=470e-9 L=60e-9 MR=1
MNM5 outn out VSS VPW nm1p2_svt_lp W=470e-9 L=60e-9 MR=1
MNM4 out AN BB VPW nm1p2_svt_lp W=470e-9 L=60e-9 MR=1
MNM3 out A BN VPW nm1p2_svt_lp W=470e-9 L=60e-9 MR=1
MNM2 BB BN VSS VPW nm1p2_svt_lp W=230n L=60n MR=1
MNM1 BN B VSS VPW nm1p2_svt_lp W=230n L=60n MR=1
MNM0 AN A VSS VPW nm1p2_svt_lp W=180n L=60n MR=1
MPM11 Y net33 VDD VNW pm1p2_svt_lp W=1.18e-6 L=60e-9 MR=1
MPM10 net33 out CC VNW pm1p2_svt_lp W=590e-9 L=60e-9 MR=1
MPM9 net33 outn CN VNW pm1p2_svt_lp W=590e-9 L=60e-9 MR=1
MPM8 CC CN VDD VNW pm1p2_svt_lp W=590e-9 L=60e-9 MR=1
MPM7 CN C VDD VNW pm1p2_svt_lp W=590e-9 L=60e-9 MR=1
MPM5 outn out VDD VNW pm1p2_svt_lp W=590e-9 L=60e-9 MR=1
MPM4 out A BB VNW pm1p2_svt_lp W=590e-9 L=60e-9 MR=1
MPM3 out AN BN VNW pm1p2_svt_lp W=590e-9 L=60e-9 MR=1
MPM2 BB BN VDD VNW pm1p2_svt_lp W=300n L=60n MR=1
MPM1 BN B VDD VNW pm1p2_svt_lp W=300n L=60n MR=1
MPM0 AN A VDD VNW pm1p2_svt_lp W=300e-9 L=60e-9 MR=1
.ENDS
.SUBCKT XNOR3X4_9TSVT A B C VDD VSS Y VNW VPW
MNM11 Y net33 VSS VPW nm1p2_svt_lp W=1.88e-6 L=60e-9 MR=1
MNM10 net33 outn CC VPW nm1p2_svt_lp W=470e-9 L=60e-9 MR=1
MNM9 net33 out CN VPW nm1p2_svt_lp W=470e-9 L=60e-9 MR=1
MNM8 CC CN VSS VPW nm1p2_svt_lp W=940n L=60n MR=1
MNM7 CN C VSS VPW nm1p2_svt_lp W=940e-9 L=60e-9 MR=1
MNM5 outn out VSS VPW nm1p2_svt_lp W=470e-9 L=60e-9 MR=1
MNM4 out AN BB VPW nm1p2_svt_lp W=470e-9 L=60e-9 MR=1
MNM3 out A BN VPW nm1p2_svt_lp W=470e-9 L=60e-9 MR=1
MNM2 BB BN VSS VPW nm1p2_svt_lp W=230n L=60n MR=1
MNM1 BN B VSS VPW nm1p2_svt_lp W=230n L=60n MR=1
MNM0 AN A VSS VPW nm1p2_svt_lp W=230n L=60n MR=1
MPM11 Y net33 VDD VNW pm1p2_svt_lp W=2.36e-6 L=60e-9 MR=1
MPM10 net33 out CC VNW pm1p2_svt_lp W=590e-9 L=60e-9 MR=1
MPM9 net33 outn CN VNW pm1p2_svt_lp W=590e-9 L=60e-9 MR=1
MPM8 CC CN VDD VNW pm1p2_svt_lp W=1.18u L=60n MR=1
MPM7 CN C VDD VNW pm1p2_svt_lp W=1.18e-6 L=60e-9 MR=1
MPM5 outn out VDD VNW pm1p2_svt_lp W=590e-9 L=60e-9 MR=1
MPM4 out A BB VNW pm1p2_svt_lp W=590e-9 L=60e-9 MR=1
MPM3 out AN BN VNW pm1p2_svt_lp W=590e-9 L=60e-9 MR=1
MPM2 BB BN VDD VNW pm1p2_svt_lp W=300n L=60n MR=1
MPM1 BN B VDD VNW pm1p2_svt_lp W=300n L=60n MR=1
MPM0 AN A VDD VNW pm1p2_svt_lp W=300n L=60n MR=1
.ENDS
.SUBCKT XNOR3X8_9TSVT A B C VDD VSS Y VNW VPW
MNM11 Y net33 VSS VPW nm1p2_svt_lp W=3.76e-6 L=60e-9 MR=1
MNM10 net33 outn CC VPW nm1p2_svt_lp W=470e-9 L=60e-9 MR=1
MNM9 net33 out CN VPW nm1p2_svt_lp W=470e-9 L=60e-9 MR=1
MNM8 CC CN VSS VPW nm1p2_svt_lp W=1.41u L=60n MR=1
MNM7 CN C VSS VPW nm1p2_svt_lp W=1.41e-6 L=60e-9 MR=1
MNM5 outn out VSS VPW nm1p2_svt_lp W=470e-9 L=60e-9 MR=1
MNM4 out AN BB VPW nm1p2_svt_lp W=470e-9 L=60e-9 MR=1
MNM3 out A BN VPW nm1p2_svt_lp W=470e-9 L=60e-9 MR=1
MNM2 BB BN VSS VPW nm1p2_svt_lp W=230n L=60n MR=1
MNM1 BN B VSS VPW nm1p2_svt_lp W=230n L=60n MR=1
MNM0 AN A VSS VPW nm1p2_svt_lp W=230n L=60n MR=1
MPM11 Y net33 VDD VNW pm1p2_svt_lp W=4.72e-6 L=60e-9 MR=1
MPM10 net33 out CC VNW pm1p2_svt_lp W=590e-9 L=60e-9 MR=1
MPM9 net33 outn CN VNW pm1p2_svt_lp W=590e-9 L=60e-9 MR=1
MPM8 CC CN VDD VNW pm1p2_svt_lp W=1.77u L=60n MR=1
MPM7 CN C VDD VNW pm1p2_svt_lp W=1.77e-6 L=60e-9 MR=1
MPM5 outn out VDD VNW pm1p2_svt_lp W=590e-9 L=60e-9 MR=1
MPM4 out A BB VNW pm1p2_svt_lp W=590e-9 L=60e-9 MR=1
MPM3 out AN BN VNW pm1p2_svt_lp W=590e-9 L=60e-9 MR=1
MPM2 BB BN VDD VNW pm1p2_svt_lp W=300n L=60n MR=1
MPM1 BN B VDD VNW pm1p2_svt_lp W=300n L=60n MR=1
MPM0 AN A VDD VNW pm1p2_svt_lp W=300n L=60n MR=1
.ENDS
.SUBCKT XNOR4X0P5_9TSVT A B C D VDD VSS Y VNW VPW
MNM14 Y net35 VSS VPW nm1p2_svt_lp W=230e-9 L=60e-9 MR=1
MNM13 net35 out1n out2 VPW nm1p2_svt_lp W=230e-9 L=60e-9 MR=1
MNM12 net35 out1 out2n VPW nm1p2_svt_lp W=230e-9 L=60e-9 MR=1
MNM11 out2n out2 VSS VPW nm1p2_svt_lp W=230e-9 L=60e-9 MR=1
MNM10 out2 CN DD VPW nm1p2_svt_lp W=230e-9 L=60e-9 MR=1
MNM9 out2 C DN VPW nm1p2_svt_lp W=230e-9 L=60e-9 MR=1
MNM8 DD DN VSS VPW nm1p2_svt_lp W=230e-9 L=60e-9 MR=1
MNM7 DN D VSS VPW nm1p2_svt_lp W=230e-9 L=60e-9 MR=1
MNM6 CN C VSS VPW nm1p2_svt_lp W=230e-9 L=60e-9 MR=1
MNM5 out1n out1 VSS VPW nm1p2_svt_lp W=230e-9 L=60e-9 MR=1
MNM4 out1 AN BB VPW nm1p2_svt_lp W=230e-9 L=60e-9 MR=1
MNM3 out1 A BN VPW nm1p2_svt_lp W=230e-9 L=60e-9 MR=1
MNM2 BB BN VSS VPW nm1p2_svt_lp W=230e-9 L=60e-9 MR=1
MNM1 BN B VSS VPW nm1p2_svt_lp W=230e-9 L=60e-9 MR=1
MNM0 AN A VSS VPW nm1p2_svt_lp W=230e-9 L=60e-9 MR=1
MPM14 Y net35 VDD VNW pm1p2_svt_lp W=300e-9 L=60e-9 MR=1
MPM13 net35 out1 out2 VNW pm1p2_svt_lp W=300e-9 L=60e-9 MR=1
MPM12 net35 out1n out2n VNW pm1p2_svt_lp W=300e-9 L=60e-9 MR=1
MPM11 out2n out2 VDD VNW pm1p2_svt_lp W=300e-9 L=60e-9 MR=1
MPM10 out2 C DD VNW pm1p2_svt_lp W=300e-9 L=60e-9 MR=1
MPM9 out2 CN DN VNW pm1p2_svt_lp W=300e-9 L=60e-9 MR=1
MPM8 DD DN VDD VNW pm1p2_svt_lp W=300e-9 L=60e-9 MR=1
MPM7 DN D VDD VNW pm1p2_svt_lp W=300e-9 L=60e-9 MR=1
MPM6 CN C VDD VNW pm1p2_svt_lp W=300e-9 L=60e-9 MR=1
MPM5 out1n out1 VDD VNW pm1p2_svt_lp W=300e-9 L=60e-9 MR=1
MPM4 out1 A BB VNW pm1p2_svt_lp W=300e-9 L=60e-9 MR=1
MPM3 out1 AN BN VNW pm1p2_svt_lp W=300e-9 L=60e-9 MR=1
MPM2 BB BN VDD VNW pm1p2_svt_lp W=300e-9 L=60e-9 MR=1
MPM1 BN B VDD VNW pm1p2_svt_lp W=300e-9 L=60e-9 MR=1
MPM0 AN A VDD VNW pm1p2_svt_lp W=300e-9 L=60e-9 MR=1
.ENDS
.SUBCKT XNOR4X1_9TSVT A B C D VDD VSS Y VNW VPW
MNM14 Y net35 VSS VPW nm1p2_svt_lp W=470e-9 L=60e-9 MR=1
MNM13 net35 out1n out2 VPW nm1p2_svt_lp W=230e-9 L=60e-9 MR=1
MNM12 net35 out1 out2n VPW nm1p2_svt_lp W=230e-9 L=60e-9 MR=1
MNM11 out2n out2 VSS VPW nm1p2_svt_lp W=230e-9 L=60e-9 MR=1
MNM10 out2 CN DD VPW nm1p2_svt_lp W=230e-9 L=60e-9 MR=1
MNM9 out2 C DN VPW nm1p2_svt_lp W=230e-9 L=60e-9 MR=1
MNM8 DD DN VSS VPW nm1p2_svt_lp W=230e-9 L=60e-9 MR=1
MNM7 DN D VSS VPW nm1p2_svt_lp W=230e-9 L=60e-9 MR=1
MNM6 CN C VSS VPW nm1p2_svt_lp W=230e-9 L=60e-9 MR=1
MNM5 out1n out1 VSS VPW nm1p2_svt_lp W=230e-9 L=60e-9 MR=1
MNM4 out1 AN BB VPW nm1p2_svt_lp W=230e-9 L=60e-9 MR=1
MNM3 out1 A BN VPW nm1p2_svt_lp W=230e-9 L=60e-9 MR=1
MNM2 BB BN VSS VPW nm1p2_svt_lp W=230e-9 L=60e-9 MR=1
MNM1 BN B VSS VPW nm1p2_svt_lp W=230e-9 L=60e-9 MR=1
MNM0 AN A VSS VPW nm1p2_svt_lp W=230e-9 L=60e-9 MR=1
MPM14 Y net35 VDD VNW pm1p2_svt_lp W=590e-9 L=60e-9 MR=1
MPM13 net35 out1 out2 VNW pm1p2_svt_lp W=300e-9 L=60e-9 MR=1
MPM12 net35 out1n out2n VNW pm1p2_svt_lp W=300e-9 L=60e-9 MR=1
MPM11 out2n out2 VDD VNW pm1p2_svt_lp W=300e-9 L=60e-9 MR=1
MPM10 out2 C DD VNW pm1p2_svt_lp W=300e-9 L=60e-9 MR=1
MPM9 out2 CN DN VNW pm1p2_svt_lp W=300e-9 L=60e-9 MR=1
MPM8 DD DN VDD VNW pm1p2_svt_lp W=300e-9 L=60e-9 MR=1
MPM7 DN D VDD VNW pm1p2_svt_lp W=300e-9 L=60e-9 MR=1
MPM6 CN C VDD VNW pm1p2_svt_lp W=300e-9 L=60e-9 MR=1
MPM5 out1n out1 VDD VNW pm1p2_svt_lp W=300e-9 L=60e-9 MR=1
MPM4 out1 A BB VNW pm1p2_svt_lp W=300e-9 L=60e-9 MR=1
MPM3 out1 AN BN VNW pm1p2_svt_lp W=300e-9 L=60e-9 MR=1
MPM2 BB BN VDD VNW pm1p2_svt_lp W=300e-9 L=60e-9 MR=1
MPM1 BN B VDD VNW pm1p2_svt_lp W=300e-9 L=60e-9 MR=1
MPM0 AN A VDD VNW pm1p2_svt_lp W=300e-9 L=60e-9 MR=1
.ENDS
.SUBCKT XNOR4X2_9TSVT A B C D VDD VSS Y VNW VPW
MNM14 Y net35 VSS VPW nm1p2_svt_lp W=940e-9 L=60e-9 MR=1
MNM13 net35 out1n out2 VPW nm1p2_svt_lp W=470e-9 L=60e-9 MR=1
MNM12 net35 out1 out2n VPW nm1p2_svt_lp W=470e-9 L=60e-9 MR=1
MNM11 out2n out2 VSS VPW nm1p2_svt_lp W=470e-9 L=60e-9 MR=1
MNM10 out2 CN DD VPW nm1p2_svt_lp W=470e-9 L=60e-9 MR=1
MNM9 out2 C DN VPW nm1p2_svt_lp W=470e-9 L=60e-9 MR=1
MNM8 DD DN VSS VPW nm1p2_svt_lp W=230n L=60n MR=1
MNM7 DN D VSS VPW nm1p2_svt_lp W=230n L=60n MR=1
MNM6 CN C VSS VPW nm1p2_svt_lp W=180e-9 L=60e-9 MR=1
MNM5 out1n out1 VSS VPW nm1p2_svt_lp W=290e-9 L=60e-9 MR=1
MNM4 out1 AN BB VPW nm1p2_svt_lp W=470e-9 L=60e-9 MR=1
MNM3 out1 A BN VPW nm1p2_svt_lp W=470e-9 L=60e-9 MR=1
MNM2 BB BN VSS VPW nm1p2_svt_lp W=230n L=60n MR=1
MNM1 BN B VSS VPW nm1p2_svt_lp W=230n L=60n MR=1
MNM0 AN A VSS VPW nm1p2_svt_lp W=180e-9 L=60e-9 MR=1
MPM14 Y net35 VDD VNW pm1p2_svt_lp W=1.18e-6 L=60e-9 MR=1
MPM13 net35 out1 out2 VNW pm1p2_svt_lp W=590e-9 L=60e-9 MR=1
MPM12 net35 out1n out2n VNW pm1p2_svt_lp W=590e-9 L=60e-9 MR=1
MPM11 out2n out2 VDD VNW pm1p2_svt_lp W=590e-9 L=60e-9 MR=1
MPM10 out2 C DD VNW pm1p2_svt_lp W=590e-9 L=60e-9 MR=1
MPM9 out2 CN DN VNW pm1p2_svt_lp W=590e-9 L=60e-9 MR=1
MPM8 DD DN VDD VNW pm1p2_svt_lp W=300n L=60n MR=1
MPM7 DN D VDD VNW pm1p2_svt_lp W=300n L=60n MR=1
MPM6 CN C VDD VNW pm1p2_svt_lp W=300e-9 L=60e-9 MR=1
MPM5 out1n out1 VDD VNW pm1p2_svt_lp W=590e-9 L=60e-9 MR=1
MPM4 out1 A BB VNW pm1p2_svt_lp W=590e-9 L=60e-9 MR=1
MPM3 out1 AN BN VNW pm1p2_svt_lp W=590e-9 L=60e-9 MR=1
MPM2 BB BN VDD VNW pm1p2_svt_lp W=300n L=60n MR=1
MPM1 BN B VDD VNW pm1p2_svt_lp W=300n L=60n MR=1
MPM0 AN A VDD VNW pm1p2_svt_lp W=300e-9 L=60e-9 MR=1
.ENDS
.SUBCKT XNOR4X4_9TSVT A B C D VDD VSS Y VNW VPW
MNM14 Y net35 VSS VPW nm1p2_svt_lp W=1.88e-6 L=60e-9 MR=1
MNM13 net35 out1n out2 VPW nm1p2_svt_lp W=470e-9 L=60e-9 MR=1
MNM12 net35 out1 out2n VPW nm1p2_svt_lp W=470e-9 L=60e-9 MR=1
MNM11 out2n out2 VSS VPW nm1p2_svt_lp W=940n L=60n MR=1
MNM10 out2 CN DD VPW nm1p2_svt_lp W=470e-9 L=60e-9 MR=1
MNM9 out2 C DN VPW nm1p2_svt_lp W=470e-9 L=60e-9 MR=1
MNM8 DD DN VSS VPW nm1p2_svt_lp W=470n L=60n MR=1
MNM7 DN D VSS VPW nm1p2_svt_lp W=470n L=60n MR=1
MNM6 CN C VSS VPW nm1p2_svt_lp W=230n L=60n MR=1
MNM5 out1n out1 VSS VPW nm1p2_svt_lp W=290n L=60n MR=1
MNM4 out1 AN BB VPW nm1p2_svt_lp W=470e-9 L=60e-9 MR=1
MNM3 out1 A BN VPW nm1p2_svt_lp W=470e-9 L=60e-9 MR=1
MNM2 BB BN VSS VPW nm1p2_svt_lp W=230n L=60n MR=1
MNM1 BN B VSS VPW nm1p2_svt_lp W=230n L=60n MR=1
MNM0 AN A VSS VPW nm1p2_svt_lp W=230n L=60n MR=1
MPM14 Y net35 VDD VNW pm1p2_svt_lp W=2.36e-6 L=60e-9 MR=1
MPM13 net35 out1 out2 VNW pm1p2_svt_lp W=590e-9 L=60e-9 MR=1
MPM12 net35 out1n out2n VNW pm1p2_svt_lp W=590e-9 L=60e-9 MR=1
MPM11 out2n out2 VDD VNW pm1p2_svt_lp W=1.18u L=60n MR=1
MPM10 out2 C DD VNW pm1p2_svt_lp W=590e-9 L=60e-9 MR=1
MPM9 out2 CN DN VNW pm1p2_svt_lp W=590e-9 L=60e-9 MR=1
MPM8 DD DN VDD VNW pm1p2_svt_lp W=590n L=60n MR=1
MPM7 DN D VDD VNW pm1p2_svt_lp W=590n L=60n MR=1
MPM6 CN C VDD VNW pm1p2_svt_lp W=300n L=60n MR=1
MPM5 out1n out1 VDD VNW pm1p2_svt_lp W=590n L=60n MR=1
MPM4 out1 A BB VNW pm1p2_svt_lp W=590e-9 L=60e-9 MR=1
MPM3 out1 AN BN VNW pm1p2_svt_lp W=370e-9 L=60e-9 MR=1
MPM2 BB BN VDD VNW pm1p2_svt_lp W=300n L=60n MR=1
MPM1 BN B VDD VNW pm1p2_svt_lp W=300n L=60n MR=1
MPM0 AN A VDD VNW pm1p2_svt_lp W=300n L=60n MR=1
.ENDS
.SUBCKT XOR2X0P5_9TSVT A B VDD VSS Y VNW VPW
MNM5 Y net16 VSS VPW nm1p2_svt_lp W=230e-9 L=60e-9 MR=1
MNM4 net16 AN BN VPW nm1p2_svt_lp W=230e-9 L=60e-9 MR=1
MNM3 net16 A BB VPW nm1p2_svt_lp W=230e-9 L=60e-9 MR=1
MNM2 BB BN VSS VPW nm1p2_svt_lp W=230e-9 L=60e-9 MR=1
MNM1 BN B VSS VPW nm1p2_svt_lp W=230e-9 L=60e-9 MR=1
MNM0 AN A VSS VPW nm1p2_svt_lp W=230e-9 L=60e-9 MR=1
MPM5 Y net16 VDD VNW pm1p2_svt_lp W=300e-9 L=60e-9 MR=1
MPM4 net16 A BN VNW pm1p2_svt_lp W=300e-9 L=60e-9 MR=1
MPM3 net16 AN BB VNW pm1p2_svt_lp W=300e-9 L=60e-9 MR=1
MPM2 BB BN VDD VNW pm1p2_svt_lp W=300e-9 L=60e-9 MR=1
MPM1 BN B VDD VNW pm1p2_svt_lp W=300e-9 L=60e-9 MR=1
MPM0 AN A VDD VNW pm1p2_svt_lp W=300e-9 L=60e-9 MR=1
.ENDS
.SUBCKT XOR2X1_9TSVT A B VDD VSS Y VNW VPW
MNM5 Y net16 VSS VPW nm1p2_svt_lp W=470e-9 L=60e-9 MR=1
MNM4 net16 AN BN VPW nm1p2_svt_lp W=230e-9 L=60e-9 MR=1
MNM3 net16 A BB VPW nm1p2_svt_lp W=230e-9 L=60e-9 MR=1
MNM2 BB BN VSS VPW nm1p2_svt_lp W=230e-9 L=60e-9 MR=1
MNM1 BN B VSS VPW nm1p2_svt_lp W=230e-9 L=60e-9 MR=1
MNM0 AN A VSS VPW nm1p2_svt_lp W=230e-9 L=60e-9 MR=1
MPM5 Y net16 VDD VNW pm1p2_svt_lp W=590e-9 L=60e-9 MR=1
MPM4 net16 A BN VNW pm1p2_svt_lp W=300e-9 L=60e-9 MR=1
MPM3 net16 AN BB VNW pm1p2_svt_lp W=300e-9 L=60e-9 MR=1
MPM2 BB BN VDD VNW pm1p2_svt_lp W=300e-9 L=60e-9 MR=1
MPM1 BN B VDD VNW pm1p2_svt_lp W=300e-9 L=60e-9 MR=1
MPM0 AN A VDD VNW pm1p2_svt_lp W=300e-9 L=60e-9 MR=1
.ENDS
.SUBCKT XOR2X2_9TSVT A B VDD VSS Y VNW VPW
MNM5 Y net16 VSS VPW nm1p2_svt_lp W=940e-9 L=60e-9 MR=1
MNM4 net16 AN BN VPW nm1p2_svt_lp W=470e-9 L=60e-9 MR=1
MNM3 net16 A BB VPW nm1p2_svt_lp W=470e-9 L=60e-9 MR=1
MNM2 BB BN VSS VPW nm1p2_svt_lp W=470e-9 L=60e-9 MR=1
MNM1 BN B VSS VPW nm1p2_svt_lp W=470e-9 L=60e-9 MR=1
MNM0 AN A VSS VPW nm1p2_svt_lp W=180e-9 L=60e-9 MR=1
MPM5 Y net16 VDD VNW pm1p2_svt_lp W=1.18e-6 L=60e-9 MR=1
MPM4 net16 A BN VNW pm1p2_svt_lp W=590e-9 L=60e-9 MR=1
MPM3 net16 AN BB VNW pm1p2_svt_lp W=590e-9 L=60e-9 MR=1
MPM2 BB BN VDD VNW pm1p2_svt_lp W=590e-9 L=60e-9 MR=1
MPM1 BN B VDD VNW pm1p2_svt_lp W=590e-9 L=60e-9 MR=1
MPM0 AN A VDD VNW pm1p2_svt_lp W=300e-9 L=60e-9 MR=1
.ENDS
.SUBCKT XOR2X4_9TSVT A B VDD VSS Y VNW VPW
MNM5 Y net16 VSS VPW nm1p2_svt_lp W=1.88e-6 L=60e-9 MR=1
MNM4 net16 AN BN VPW nm1p2_svt_lp W=470e-9 L=60e-9 MR=1
MNM3 net16 A BB VPW nm1p2_svt_lp W=470e-9 L=60e-9 MR=1
MNM2 BB BN VSS VPW nm1p2_svt_lp W=940n L=60n MR=1
MNM1 BN B VSS VPW nm1p2_svt_lp W=940e-9 L=60e-9 MR=1
MNM0 AN A VSS VPW nm1p2_svt_lp W=230n L=60n MR=1
MPM5 Y net16 VDD VNW pm1p2_svt_lp W=2.36e-6 L=60e-9 MR=1
MPM4 net16 A BN VNW pm1p2_svt_lp W=590e-9 L=60e-9 MR=1
MPM3 net16 AN BB VNW pm1p2_svt_lp W=590e-9 L=60e-9 MR=1
MPM2 BB BN VDD VNW pm1p2_svt_lp W=1.18u L=60n MR=1
MPM1 BN B VDD VNW pm1p2_svt_lp W=1.18e-6 L=60e-9 MR=1
MPM0 AN A VDD VNW pm1p2_svt_lp W=300n L=60n MR=1
.ENDS
.SUBCKT XOR2X8_9TSVT A B VDD VSS Y VNW VPW
MNM5 Y net16 VSS VPW nm1p2_svt_lp W=3.76e-6 L=60e-9 MR=1
MNM4 net16 AN BN VPW nm1p2_svt_lp W=470e-9 L=60e-9 MR=1
MNM3 net16 A BB VPW nm1p2_svt_lp W=470e-9 L=60e-9 MR=1
MNM2 BB BN VSS VPW nm1p2_svt_lp W=1.41u L=60n MR=1
MNM1 BN B VSS VPW nm1p2_svt_lp W=1.41e-6 L=60e-9 MR=1
MNM0 AN A VSS VPW nm1p2_svt_lp W=230n L=60n MR=1
MPM5 Y net16 VDD VNW pm1p2_svt_lp W=4.72e-6 L=60e-9 MR=1
MPM4 net16 A BN VNW pm1p2_svt_lp W=590e-9 L=60e-9 MR=1
MPM3 net16 AN BB VNW pm1p2_svt_lp W=590e-9 L=60e-9 MR=1
MPM2 BB BN VDD VNW pm1p2_svt_lp W=1.77u L=60n MR=1
MPM1 BN B VDD VNW pm1p2_svt_lp W=1.77e-6 L=60e-9 MR=1
MPM0 AN A VDD VNW pm1p2_svt_lp W=300n L=60n MR=1
.ENDS
.SUBCKT XOR3X0P5_9TSVT A B C VDD VSS Y VNW VPW
MNM11 Y net33 VSS VPW nm1p2_svt_lp W=230e-9 L=60e-9 MR=1
MNM10 net33 out CN VPW nm1p2_svt_lp W=230e-9 L=60e-9 MR=1
MNM9 net33 outn CC VPW nm1p2_svt_lp W=230e-9 L=60e-9 MR=1
MNM8 CC CN VSS VPW nm1p2_svt_lp W=230e-9 L=60e-9 MR=1
MNM7 CN C VSS VPW nm1p2_svt_lp W=230e-9 L=60e-9 MR=1
MNM5 outn out VSS VPW nm1p2_svt_lp W=230e-9 L=60e-9 MR=1
MNM4 out AN BN VPW nm1p2_svt_lp W=230e-9 L=60e-9 MR=1
MNM3 out A BB VPW nm1p2_svt_lp W=230e-9 L=60e-9 MR=1
MNM2 BB BN VSS VPW nm1p2_svt_lp W=230e-9 L=60e-9 MR=1
MNM1 BN B VSS VPW nm1p2_svt_lp W=230e-9 L=60e-9 MR=1
MNM0 AN A VSS VPW nm1p2_svt_lp W=230e-9 L=60e-9 MR=1
MPM11 Y net33 VDD VNW pm1p2_svt_lp W=300e-9 L=60e-9 MR=1
MPM10 net33 outn CN VNW pm1p2_svt_lp W=300e-9 L=60e-9 MR=1
MPM9 net33 out CC VNW pm1p2_svt_lp W=300e-9 L=60e-9 MR=1
MPM8 CC CN VDD VNW pm1p2_svt_lp W=300e-9 L=60e-9 MR=1
MPM7 CN C VDD VNW pm1p2_svt_lp W=300e-9 L=60e-9 MR=1
MPM5 outn out VDD VNW pm1p2_svt_lp W=300e-9 L=60e-9 MR=1
MPM4 out A BN VNW pm1p2_svt_lp W=300e-9 L=60e-9 MR=1
MPM3 out AN BB VNW pm1p2_svt_lp W=300e-9 L=60e-9 MR=1
MPM2 BB BN VDD VNW pm1p2_svt_lp W=300e-9 L=60e-9 MR=1
MPM1 BN B VDD VNW pm1p2_svt_lp W=300e-9 L=60e-9 MR=1
MPM0 AN A VDD VNW pm1p2_svt_lp W=300e-9 L=60e-9 MR=1
.ENDS
.SUBCKT XOR3X1_9TSVT A B C VDD VSS Y VNW VPW
MNM11 Y net33 VSS VPW nm1p2_svt_lp W=470e-9 L=60e-9 MR=1
MNM10 net33 out CN VPW nm1p2_svt_lp W=230e-9 L=60e-9 MR=1
MNM9 net33 outn CC VPW nm1p2_svt_lp W=230e-9 L=60e-9 MR=1
MNM8 CC CN VSS VPW nm1p2_svt_lp W=230e-9 L=60e-9 MR=1
MNM7 CN C VSS VPW nm1p2_svt_lp W=230e-9 L=60e-9 MR=1
MNM5 outn out VSS VPW nm1p2_svt_lp W=230e-9 L=60e-9 MR=1
MNM4 out AN BN VPW nm1p2_svt_lp W=230e-9 L=60e-9 MR=1
MNM3 out A BB VPW nm1p2_svt_lp W=230e-9 L=60e-9 MR=1
MNM2 BB BN VSS VPW nm1p2_svt_lp W=230e-9 L=60e-9 MR=1
MNM1 BN B VSS VPW nm1p2_svt_lp W=230e-9 L=60e-9 MR=1
MNM0 AN A VSS VPW nm1p2_svt_lp W=230e-9 L=60e-9 MR=1
MPM11 Y net33 VDD VNW pm1p2_svt_lp W=590e-9 L=60e-9 MR=1
MPM10 net33 outn CN VNW pm1p2_svt_lp W=300e-9 L=60e-9 MR=1
MPM9 net33 out CC VNW pm1p2_svt_lp W=300e-9 L=60e-9 MR=1
MPM8 CC CN VDD VNW pm1p2_svt_lp W=300e-9 L=60e-9 MR=1
MPM7 CN C VDD VNW pm1p2_svt_lp W=300e-9 L=60e-9 MR=1
MPM5 outn out VDD VNW pm1p2_svt_lp W=300e-9 L=60e-9 MR=1
MPM4 out A BN VNW pm1p2_svt_lp W=300e-9 L=60e-9 MR=1
MPM3 out AN BB VNW pm1p2_svt_lp W=300e-9 L=60e-9 MR=1
MPM2 BB BN VDD VNW pm1p2_svt_lp W=300e-9 L=60e-9 MR=1
MPM1 BN B VDD VNW pm1p2_svt_lp W=300e-9 L=60e-9 MR=1
MPM0 AN A VDD VNW pm1p2_svt_lp W=300e-9 L=60e-9 MR=1
.ENDS
.SUBCKT XOR3X2_9TSVT A B C VDD VSS Y VNW VPW
MNM11 Y net33 VSS VPW nm1p2_svt_lp W=940e-9 L=60e-9 MR=1
MNM10 net33 out CN VPW nm1p2_svt_lp W=470e-9 L=60e-9 MR=1
MNM9 net33 outn CC VPW nm1p2_svt_lp W=470e-9 L=60e-9 MR=1
MNM8 CC CN VSS VPW nm1p2_svt_lp W=470e-9 L=60e-9 MR=1
MNM7 CN C VSS VPW nm1p2_svt_lp W=470e-9 L=60e-9 MR=1
MNM5 outn out VSS VPW nm1p2_svt_lp W=470e-9 L=60e-9 MR=1
MNM4 out AN BN VPW nm1p2_svt_lp W=470e-9 L=60e-9 MR=1
MNM3 out A BB VPW nm1p2_svt_lp W=470e-9 L=60e-9 MR=1
MNM2 BB BN VSS VPW nm1p2_svt_lp W=230n L=60n MR=1
MNM1 BN B VSS VPW nm1p2_svt_lp W=230n L=60n MR=1
MNM0 AN A VSS VPW nm1p2_svt_lp W=180e-9 L=60e-9 MR=1
MPM11 Y net33 VDD VNW pm1p2_svt_lp W=1.18e-6 L=60e-9 MR=1
MPM10 net33 outn CN VNW pm1p2_svt_lp W=590e-9 L=60e-9 MR=1
MPM9 net33 out CC VNW pm1p2_svt_lp W=590e-9 L=60e-9 MR=1
MPM8 CC CN VDD VNW pm1p2_svt_lp W=590e-9 L=60e-9 MR=1
MPM7 CN C VDD VNW pm1p2_svt_lp W=590e-9 L=60e-9 MR=1
MPM5 outn out VDD VNW pm1p2_svt_lp W=590e-9 L=60e-9 MR=1
MPM4 out A BN VNW pm1p2_svt_lp W=590e-9 L=60e-9 MR=1
MPM3 out AN BB VNW pm1p2_svt_lp W=590e-9 L=60e-9 MR=1
MPM2 BB BN VDD VNW pm1p2_svt_lp W=300n L=60n MR=1
MPM1 BN B VDD VNW pm1p2_svt_lp W=300n L=60n MR=1
MPM0 AN A VDD VNW pm1p2_svt_lp W=300e-9 L=60e-9 MR=1
.ENDS
.SUBCKT XOR3X4_9TSVT A B C VDD VSS Y VNW VPW
MNM11 Y net33 VSS VPW nm1p2_svt_lp W=1.88e-6 L=60e-9 MR=1
MNM10 net33 out CN VPW nm1p2_svt_lp W=470e-9 L=60e-9 MR=1
MNM9 net33 outn CC VPW nm1p2_svt_lp W=470e-9 L=60e-9 MR=1
MNM8 CC CN VSS VPW nm1p2_svt_lp W=940n L=60n MR=1
MNM7 CN C VSS VPW nm1p2_svt_lp W=940e-9 L=60e-9 MR=1
MNM5 outn out VSS VPW nm1p2_svt_lp W=470e-9 L=60e-9 MR=1
MNM4 out AN BN VPW nm1p2_svt_lp W=470e-9 L=60e-9 MR=1
MNM3 out A BB VPW nm1p2_svt_lp W=470e-9 L=60e-9 MR=1
MNM2 BB BN VSS VPW nm1p2_svt_lp W=230n L=60n MR=1
MNM1 BN B VSS VPW nm1p2_svt_lp W=230n L=60n MR=1
MNM0 AN A VSS VPW nm1p2_svt_lp W=230n L=60n MR=1
MPM11 Y net33 VDD VNW pm1p2_svt_lp W=2.36e-6 L=60e-9 MR=1
MPM10 net33 outn CN VNW pm1p2_svt_lp W=590e-9 L=60e-9 MR=1
MPM9 net33 out CC VNW pm1p2_svt_lp W=590e-9 L=60e-9 MR=1
MPM8 CC CN VDD VNW pm1p2_svt_lp W=1.18u L=60n MR=1
MPM7 CN C VDD VNW pm1p2_svt_lp W=1.18e-6 L=60e-9 MR=1
MPM5 outn out VDD VNW pm1p2_svt_lp W=590e-9 L=60e-9 MR=1
MPM4 out A BN VNW pm1p2_svt_lp W=590e-9 L=60e-9 MR=1
MPM3 out AN BB VNW pm1p2_svt_lp W=590e-9 L=60e-9 MR=1
MPM2 BB BN VDD VNW pm1p2_svt_lp W=300n L=60n MR=1
MPM1 BN B VDD VNW pm1p2_svt_lp W=300n L=60n MR=1
MPM0 AN A VDD VNW pm1p2_svt_lp W=300n L=60n MR=1
.ENDS
.SUBCKT XOR3X8_9TSVT A B C VDD VSS Y VNW VPW
MNM11 Y net33 VSS VPW nm1p2_svt_lp W=3.76e-6 L=60e-9 MR=1
MNM10 net33 out CN VPW nm1p2_svt_lp W=470e-9 L=60e-9 MR=1
MNM9 net33 outn CC VPW nm1p2_svt_lp W=470e-9 L=60e-9 MR=1
MNM8 CC CN VSS VPW nm1p2_svt_lp W=1.41u L=60n MR=1
MNM7 CN C VSS VPW nm1p2_svt_lp W=1.41e-6 L=60e-9 MR=1
MNM5 outn out VSS VPW nm1p2_svt_lp W=470e-9 L=60e-9 MR=1
MNM4 out AN BN VPW nm1p2_svt_lp W=470e-9 L=60e-9 MR=1
MNM3 out A BB VPW nm1p2_svt_lp W=470e-9 L=60e-9 MR=1
MNM2 BB BN VSS VPW nm1p2_svt_lp W=230n L=60n MR=1
MNM1 BN B VSS VPW nm1p2_svt_lp W=230n L=60n MR=1
MNM0 AN A VSS VPW nm1p2_svt_lp W=230n L=60n MR=1
MPM11 Y net33 VDD VNW pm1p2_svt_lp W=4.72e-6 L=60e-9 MR=1
MPM10 net33 outn CN VNW pm1p2_svt_lp W=590e-9 L=60e-9 MR=1
MPM9 net33 out CC VNW pm1p2_svt_lp W=590e-9 L=60e-9 MR=1
MPM8 CC CN VDD VNW pm1p2_svt_lp W=1.77u L=60n MR=1
MPM7 CN C VDD VNW pm1p2_svt_lp W=1.77e-6 L=60e-9 MR=1
MPM5 outn out VDD VNW pm1p2_svt_lp W=590e-9 L=60e-9 MR=1
MPM4 out A BN VNW pm1p2_svt_lp W=590e-9 L=60e-9 MR=1
MPM3 out AN BB VNW pm1p2_svt_lp W=590e-9 L=60e-9 MR=1
MPM2 BB BN VDD VNW pm1p2_svt_lp W=300n L=60n MR=1
MPM1 BN B VDD VNW pm1p2_svt_lp W=300n L=60n MR=1
MPM0 AN A VDD VNW pm1p2_svt_lp W=300n L=60n MR=1
.ENDS
.SUBCKT XOR4X0P5_9TSVT A B C D VDD VSS Y VNW VPW
MNM14 Y net35 VSS VPW nm1p2_svt_lp W=230e-9 L=60e-9 MR=1
MNM13 net35 out1n out2n VPW nm1p2_svt_lp W=230e-9 L=60e-9 MR=1
MNM12 net35 out1 out2 VPW nm1p2_svt_lp W=230e-9 L=60e-9 MR=1
MNM11 out2n out2 VSS VPW nm1p2_svt_lp W=230e-9 L=60e-9 MR=1
MNM10 out2 CN DN VPW nm1p2_svt_lp W=230e-9 L=60e-9 MR=1
MNM9 out2 C DD VPW nm1p2_svt_lp W=230e-9 L=60e-9 MR=1
MNM8 DD DN VSS VPW nm1p2_svt_lp W=230e-9 L=60e-9 MR=1
MNM7 DN D VSS VPW nm1p2_svt_lp W=230e-9 L=60e-9 MR=1
MNM6 CN C VSS VPW nm1p2_svt_lp W=230e-9 L=60e-9 MR=1
MNM5 out1n out1 VSS VPW nm1p2_svt_lp W=230e-9 L=60e-9 MR=1
MNM4 out1 AN BN VPW nm1p2_svt_lp W=230e-9 L=60e-9 MR=1
MNM3 out1 A BB VPW nm1p2_svt_lp W=230e-9 L=60e-9 MR=1
MNM2 BB BN VSS VPW nm1p2_svt_lp W=230e-9 L=60e-9 MR=1
MNM1 BN B VSS VPW nm1p2_svt_lp W=230e-9 L=60e-9 MR=1
MNM0 AN A VSS VPW nm1p2_svt_lp W=230e-9 L=60e-9 MR=1
MPM14 Y net35 VDD VNW pm1p2_svt_lp W=300e-9 L=60e-9 MR=1
MPM13 net35 out1 out2n VNW pm1p2_svt_lp W=300e-9 L=60e-9 MR=1
MPM12 net35 out1n out2 VNW pm1p2_svt_lp W=300e-9 L=60e-9 MR=1
MPM11 out2n out2 VDD VNW pm1p2_svt_lp W=300e-9 L=60e-9 MR=1
MPM10 out2 C DN VNW pm1p2_svt_lp W=300e-9 L=60e-9 MR=1
MPM9 out2 CN DD VNW pm1p2_svt_lp W=300e-9 L=60e-9 MR=1
MPM8 DD DN VDD VNW pm1p2_svt_lp W=300e-9 L=60e-9 MR=1
MPM7 DN D VDD VNW pm1p2_svt_lp W=300e-9 L=60e-9 MR=1
MPM6 CN C VDD VNW pm1p2_svt_lp W=300e-9 L=60e-9 MR=1
MPM5 out1n out1 VDD VNW pm1p2_svt_lp W=300e-9 L=60e-9 MR=1
MPM4 out1 A BN VNW pm1p2_svt_lp W=300e-9 L=60e-9 MR=1
MPM3 out1 AN BB VNW pm1p2_svt_lp W=300e-9 L=60e-9 MR=1
MPM2 BB BN VDD VNW pm1p2_svt_lp W=300e-9 L=60e-9 MR=1
MPM1 BN B VDD VNW pm1p2_svt_lp W=300e-9 L=60e-9 MR=1
MPM0 AN A VDD VNW pm1p2_svt_lp W=300e-9 L=60e-9 MR=1
.ENDS
.SUBCKT XOR4X1_9TSVT A B C D VDD VSS Y VNW VPW
MNM14 Y net35 VSS VPW nm1p2_svt_lp W=470e-9 L=60e-9 MR=1
MNM13 net35 out1n out2n VPW nm1p2_svt_lp W=230e-9 L=60e-9 MR=1
MNM12 net35 out1 out2 VPW nm1p2_svt_lp W=230e-9 L=60e-9 MR=1
MNM11 out2n out2 VSS VPW nm1p2_svt_lp W=230e-9 L=60e-9 MR=1
MNM10 out2 CN DN VPW nm1p2_svt_lp W=230e-9 L=60e-9 MR=1
MNM9 out2 C DD VPW nm1p2_svt_lp W=230e-9 L=60e-9 MR=1
MNM8 DD DN VSS VPW nm1p2_svt_lp W=230e-9 L=60e-9 MR=1
MNM7 DN D VSS VPW nm1p2_svt_lp W=230e-9 L=60e-9 MR=1
MNM6 CN C VSS VPW nm1p2_svt_lp W=230e-9 L=60e-9 MR=1
MNM5 out1n out1 VSS VPW nm1p2_svt_lp W=230e-9 L=60e-9 MR=1
MNM4 out1 AN BN VPW nm1p2_svt_lp W=230e-9 L=60e-9 MR=1
MNM3 out1 A BB VPW nm1p2_svt_lp W=230e-9 L=60e-9 MR=1
MNM2 BB BN VSS VPW nm1p2_svt_lp W=230e-9 L=60e-9 MR=1
MNM1 BN B VSS VPW nm1p2_svt_lp W=230e-9 L=60e-9 MR=1
MNM0 AN A VSS VPW nm1p2_svt_lp W=230e-9 L=60e-9 MR=1
MPM14 Y net35 VDD VNW pm1p2_svt_lp W=590e-9 L=60e-9 MR=1
MPM13 net35 out1 out2n VNW pm1p2_svt_lp W=300e-9 L=60e-9 MR=1
MPM12 net35 out1n out2 VNW pm1p2_svt_lp W=300e-9 L=60e-9 MR=1
MPM11 out2n out2 VDD VNW pm1p2_svt_lp W=300e-9 L=60e-9 MR=1
MPM10 out2 C DN VNW pm1p2_svt_lp W=300e-9 L=60e-9 MR=1
MPM9 out2 CN DD VNW pm1p2_svt_lp W=300e-9 L=60e-9 MR=1
MPM8 DD DN VDD VNW pm1p2_svt_lp W=300e-9 L=60e-9 MR=1
MPM7 DN D VDD VNW pm1p2_svt_lp W=300e-9 L=60e-9 MR=1
MPM6 CN C VDD VNW pm1p2_svt_lp W=300e-9 L=60e-9 MR=1
MPM5 out1n out1 VDD VNW pm1p2_svt_lp W=300e-9 L=60e-9 MR=1
MPM4 out1 A BN VNW pm1p2_svt_lp W=300e-9 L=60e-9 MR=1
MPM3 out1 AN BB VNW pm1p2_svt_lp W=300e-9 L=60e-9 MR=1
MPM2 BB BN VDD VNW pm1p2_svt_lp W=300e-9 L=60e-9 MR=1
MPM1 BN B VDD VNW pm1p2_svt_lp W=300e-9 L=60e-9 MR=1
MPM0 AN A VDD VNW pm1p2_svt_lp W=300e-9 L=60e-9 MR=1
.ENDS
.SUBCKT XOR4X2_9TSVT A B C D VDD VSS Y VNW VPW
MNM14 Y net35 VSS VPW nm1p2_svt_lp W=940e-9 L=60e-9 MR=1
MNM13 net35 out1n out2n VPW nm1p2_svt_lp W=470e-9 L=60e-9 MR=1
MNM12 net35 out1 out2 VPW nm1p2_svt_lp W=470e-9 L=60e-9 MR=1
MNM11 out2n out2 VSS VPW nm1p2_svt_lp W=470e-9 L=60e-9 MR=1
MNM10 out2 CN DN VPW nm1p2_svt_lp W=470e-9 L=60e-9 MR=1
MNM9 out2 C DD VPW nm1p2_svt_lp W=470e-9 L=60e-9 MR=1
MNM8 DD DN VSS VPW nm1p2_svt_lp W=230n L=60n MR=1
MNM7 DN D VSS VPW nm1p2_svt_lp W=230n L=60n MR=1
MNM6 CN C VSS VPW nm1p2_svt_lp W=180e-9 L=60e-9 MR=1
MNM5 out1n out1 VSS VPW nm1p2_svt_lp W=470e-9 L=60e-9 MR=1
MNM4 out1 AN BN VPW nm1p2_svt_lp W=470e-9 L=60e-9 MR=1
MNM3 out1 A BB VPW nm1p2_svt_lp W=470e-9 L=60e-9 MR=1
MNM2 BB BN VSS VPW nm1p2_svt_lp W=230n L=60n MR=1
MNM1 BN B VSS VPW nm1p2_svt_lp W=230n L=60n MR=1
MNM0 AN A VSS VPW nm1p2_svt_lp W=180e-9 L=60e-9 MR=1
MPM14 Y net35 VDD VNW pm1p2_svt_lp W=1.18e-6 L=60e-9 MR=1
MPM13 net35 out1 out2n VNW pm1p2_svt_lp W=590e-9 L=60e-9 MR=1
MPM12 net35 out1n out2 VNW pm1p2_svt_lp W=590e-9 L=60e-9 MR=1
MPM11 out2n out2 VDD VNW pm1p2_svt_lp W=590e-9 L=60e-9 MR=1
MPM10 out2 C DN VNW pm1p2_svt_lp W=590e-9 L=60e-9 MR=1
MPM9 out2 CN DD VNW pm1p2_svt_lp W=590e-9 L=60e-9 MR=1
MPM8 DD DN VDD VNW pm1p2_svt_lp W=300n L=60n MR=1
MPM7 DN D VDD VNW pm1p2_svt_lp W=300n L=60n MR=1
MPM6 CN C VDD VNW pm1p2_svt_lp W=300e-9 L=60e-9 MR=1
MPM5 out1n out1 VDD VNW pm1p2_svt_lp W=590e-9 L=60e-9 MR=1
MPM4 out1 A BN VNW pm1p2_svt_lp W=590e-9 L=60e-9 MR=1
MPM3 out1 AN BB VNW pm1p2_svt_lp W=590e-9 L=60e-9 MR=1
MPM2 BB BN VDD VNW pm1p2_svt_lp W=300n L=60n MR=1
MPM1 BN B VDD VNW pm1p2_svt_lp W=300n L=60n MR=1
MPM0 AN A VDD VNW pm1p2_svt_lp W=300e-9 L=60e-9 MR=1
.ENDS
.SUBCKT XOR4X4_9TSVT A B C D VDD VSS Y VNW VPW
MNM14 Y net35 VSS VPW nm1p2_svt_lp W=1.88e-6 L=60e-9 MR=1
MNM13 net35 out1n out2n VPW nm1p2_svt_lp W=470e-9 L=60e-9 MR=1
MNM12 net35 out1 out2 VPW nm1p2_svt_lp W=470e-9 L=60e-9 MR=1
MNM11 out2n out2 VSS VPW nm1p2_svt_lp W=940n L=60n MR=1
MNM10 out2 CN DN VPW nm1p2_svt_lp W=470e-9 L=60e-9 MR=1
MNM9 out2 C DD VPW nm1p2_svt_lp W=470e-9 L=60e-9 MR=1
MNM8 DD DN VSS VPW nm1p2_svt_lp W=470n L=60n MR=1
MNM7 DN D VSS VPW nm1p2_svt_lp W=470n L=60n MR=1
MNM6 CN C VSS VPW nm1p2_svt_lp W=230n L=60n MR=1
MNM5 out1n out1 VSS VPW nm1p2_svt_lp W=470e-9 L=60e-9 MR=1
MNM4 out1 AN BN VPW nm1p2_svt_lp W=470e-9 L=60e-9 MR=1
MNM3 out1 A BB VPW nm1p2_svt_lp W=470e-9 L=60e-9 MR=1
MNM2 BB BN VSS VPW nm1p2_svt_lp W=230n L=60n MR=1
MNM1 BN B VSS VPW nm1p2_svt_lp W=230n L=60n MR=1
MNM0 AN A VSS VPW nm1p2_svt_lp W=230n L=60n MR=1
MPM14 Y net35 VDD VNW pm1p2_svt_lp W=2.36e-6 L=60e-9 MR=1
MPM13 net35 out1 out2n VNW pm1p2_svt_lp W=590e-9 L=60e-9 MR=1
MPM12 net35 out1n out2 VNW pm1p2_svt_lp W=590e-9 L=60e-9 MR=1
MPM11 out2n out2 VDD VNW pm1p2_svt_lp W=1.18u L=60n MR=1
MPM10 out2 C DN VNW pm1p2_svt_lp W=590e-9 L=60e-9 MR=1
MPM9 out2 CN DD VNW pm1p2_svt_lp W=590e-9 L=60e-9 MR=1
MPM8 DD DN VDD VNW pm1p2_svt_lp W=590n L=60n MR=1
MPM7 DN D VDD VNW pm1p2_svt_lp W=590n L=60n MR=1
MPM6 CN C VDD VNW pm1p2_svt_lp W=300n L=60n MR=1
MPM5 out1n out1 VDD VNW pm1p2_svt_lp W=590e-9 L=60e-9 MR=1
MPM4 out1 A BN VNW pm1p2_svt_lp W=590e-9 L=60e-9 MR=1
MPM3 out1 AN BB VNW pm1p2_svt_lp W=590e-9 L=60e-9 MR=1
MPM2 BB BN VDD VNW pm1p2_svt_lp W=300n L=60n MR=1
MPM1 BN B VDD VNW pm1p2_svt_lp W=300n L=60n MR=1
MPM0 AN A VDD VNW pm1p2_svt_lp W=300n L=60n MR=1
.ENDS
.SUBCKT GAND2X1_9TSVT A B VDD VSS Y VNW VPW
MM0 VSS yn VSS VPW nm1p2_svt_lp W=470e-9 L=60e-9 MR=1
MNM2 Y yn VSS VPW nm1p2_svt_lp W=470e-9 L=60e-9 MR=1
MNM1 net19 B VSS VPW nm1p2_svt_lp W=470e-9 L=60e-9 MR=1
MNM0 yn A net19 VPW nm1p2_svt_lp W=470e-9 L=60e-9 MR=1
MM1 VDD yn VDD VNW pm1p2_svt_lp W=590e-9 L=60e-9 MR=1
MPM2 Y yn VDD VNW pm1p2_svt_lp W=590e-9 L=60e-9 MR=1
MPM1 yn B VDD VNW pm1p2_svt_lp W=590e-9 L=60e-9 MR=1
MPM0 yn A VDD VNW pm1p2_svt_lp W=590e-9 L=60e-9 MR=1
.ENDS
.SUBCKT GAND2X2_9TSVT A B VDD VSS Y VNW VPW
MNM2 Y net13 VSS VPW nm1p2_svt_lp W=940e-9 L=60e-9 MR=1
MNM1 net19 B VSS VPW nm1p2_svt_lp W=470e-9 L=60e-9 MR=1
MNM0 net13 A net19 VPW nm1p2_svt_lp W=470e-9 L=60e-9 MR=1
MPM2 Y net13 VDD VNW pm1p2_svt_lp W=1.18e-6 L=60e-9 MR=1
MPM1 net13 B VDD VNW pm1p2_svt_lp W=590e-9 L=60e-9 MR=1
MPM0 net13 A VDD VNW pm1p2_svt_lp W=590e-9 L=60e-9 MR=1
.ENDS
.SUBCKT GAND2X4_9TSVT A B VDD VSS Y VNW VPW
MNM2 Y net13 VSS VPW nm1p2_svt_lp W=1.88e-6 L=60e-9 MR=1
MNM1 net19 B VSS VPW nm1p2_svt_lp W=940e-9 L=60e-9 MR=1
MNM0 net13 A net19 VPW nm1p2_svt_lp W=940e-9 L=60e-9 MR=1
MPM2 Y net13 VDD VNW pm1p2_svt_lp W=2.36e-6 L=60e-9 MR=1
MPM1 net13 B VDD VNW pm1p2_svt_lp W=1.18e-6 L=60e-9 MR=1
MPM0 net13 A VDD VNW pm1p2_svt_lp W=1.18e-6 L=60e-9 MR=1
.ENDS
.SUBCKT GAOI21X1_9TSVT A0 A1 B0 VDD VSS Y VNW VPW
MM0 VSS B0 VSS VPW nm1p2_svt_lp W=470e-9 L=60e-9 MR=1
MNM2 Y B0 VSS VPW nm1p2_svt_lp W=470e-9 L=60e-9 MR=1
MNM1 net19 A1 VSS VPW nm1p2_svt_lp W=470e-9 L=60e-9 MR=1
MNM0 Y A0 net19 VPW nm1p2_svt_lp W=470e-9 L=60e-9 MR=1
MM1 VDD B0 VDD VNW pm1p2_svt_lp W=590e-9 L=60e-9 MR=1
MPM2 net15 B0 VDD VNW pm1p2_svt_lp W=590e-9 L=60e-9 MR=1
MPM1 Y A1 net15 VNW pm1p2_svt_lp W=590e-9 L=60e-9 MR=1
MPM0 Y A0 net15 VNW pm1p2_svt_lp W=590e-9 L=60e-9 MR=1
.ENDS
.SUBCKT GAOI21X2_9TSVT A0 A1 B0 VDD VSS Y VNW VPW
MNM2 Y B0 VSS VPW nm1p2_svt_lp W=940e-9 L=60e-9 MR=1
MNM1 net19 A1 VSS VPW nm1p2_svt_lp W=940e-9 L=60e-9 MR=1
MNM0 Y A0 net19 VPW nm1p2_svt_lp W=940e-9 L=60e-9 MR=1
MPM2 net15 B0 VDD VNW pm1p2_svt_lp W=1.18e-6 L=60e-9 MR=1
MPM1 Y A1 net15 VNW pm1p2_svt_lp W=1.18e-6 L=60e-9 MR=1
MPM0 Y A0 net15 VNW pm1p2_svt_lp W=1.18e-6 L=60e-9 MR=1
.ENDS
.SUBCKT GAOI22X1_9TSVT A0 A1 B0 B1 VDD VSS Y VNW VPW
MNM3 net23 B1 VSS VPW nm1p2_svt_lp W=470e-9 L=60e-9 MR=1
MNM2 Y B0 net23 VPW nm1p2_svt_lp W=470e-9 L=60e-9 MR=1
MNM1 net24 A1 VSS VPW nm1p2_svt_lp W=470e-9 L=60e-9 MR=1
MNM0 Y A0 net24 VPW nm1p2_svt_lp W=470e-9 L=60e-9 MR=1
MPM3 net17 B1 VDD VNW pm1p2_svt_lp W=590e-9 L=60e-9 MR=1
MPM2 net17 B0 VDD VNW pm1p2_svt_lp W=590e-9 L=60e-9 MR=1
MPM1 Y A1 net17 VNW pm1p2_svt_lp W=590e-9 L=60e-9 MR=1
MPM0 Y A0 net17 VNW pm1p2_svt_lp W=590e-9 L=60e-9 MR=1
.ENDS
.SUBCKT GAOI22X2_9TSVT A0 A1 B0 B1 VDD VSS Y VNW VPW
MNM3 net23 B1 VSS VPW nm1p2_svt_lp W=940e-9 L=60e-9 MR=1
MNM2 Y B0 net23 VPW nm1p2_svt_lp W=940e-9 L=60e-9 MR=1
MNM1 net24 A1 VSS VPW nm1p2_svt_lp W=940e-9 L=60e-9 MR=1
MNM0 Y A0 net24 VPW nm1p2_svt_lp W=940e-9 L=60e-9 MR=1
MPM3 net17 B1 VDD VNW pm1p2_svt_lp W=1.18e-6 L=60e-9 MR=1
MPM2 net17 B0 VDD VNW pm1p2_svt_lp W=1.18e-6 L=60e-9 MR=1
MPM1 Y A1 net17 VNW pm1p2_svt_lp W=1.18e-6 L=60e-9 MR=1
MPM0 Y A0 net17 VNW pm1p2_svt_lp W=1.18e-6 L=60e-9 MR=1
.ENDS
.SUBCKT GAOI31X1_9TSVT A0 A1 A2 B0 VDD VSS Y VNW VPW
MNM3 Y B0 VSS VPW nm1p2_svt_lp W=470e-9 L=60e-9 MR=1
MNM2 net23 A2 VSS VPW nm1p2_svt_lp W=470e-9 L=60e-9 MR=1
MNM1 net24 A1 net23 VPW nm1p2_svt_lp W=470e-9 L=60e-9 MR=1
MNM0 Y A0 net24 VPW nm1p2_svt_lp W=470e-9 L=60e-9 MR=1
MPM3 net21 B0 VDD VNW pm1p2_svt_lp W=590e-9 L=60e-9 MR=1
MPM2 Y A2 net21 VNW pm1p2_svt_lp W=590e-9 L=60e-9 MR=1
MPM1 Y A1 net21 VNW pm1p2_svt_lp W=590e-9 L=60e-9 MR=1
MPM0 Y A0 net21 VNW pm1p2_svt_lp W=590e-9 L=60e-9 MR=1
.ENDS
.SUBCKT GAOI31X2_9TSVT A0 A1 A2 B0 VDD VSS Y VNW VPW
MNM3 Y B0 VSS VPW nm1p2_svt_lp W=940e-9 L=60e-9 MR=1
MNM2 net23 A2 VSS VPW nm1p2_svt_lp W=940e-9 L=60e-9 MR=1
MNM1 net24 A1 net23 VPW nm1p2_svt_lp W=940e-9 L=60e-9 MR=1
MNM0 Y A0 net24 VPW nm1p2_svt_lp W=940e-9 L=60e-9 MR=1
MPM3 net21 B0 VDD VNW pm1p2_svt_lp W=1.18e-6 L=60e-9 MR=1
MPM2 Y A2 net21 VNW pm1p2_svt_lp W=1.18e-6 L=60e-9 MR=1
MPM1 Y A1 net21 VNW pm1p2_svt_lp W=1.18e-6 L=60e-9 MR=1
MPM0 Y A0 net21 VNW pm1p2_svt_lp W=1.18e-6 L=60e-9 MR=1
.ENDS
.SUBCKT GBUFX1_9TSVT A VDD VSS Y VNW VPW
MNM1 Y net11 VSS VPW nm1p2_svt_lp W=470e-9 L=60e-9 MR=1
MNM0 net11 A VSS VPW nm1p2_svt_lp W=470e-9 L=60e-9 MR=1
MPM1 Y net11 VDD VNW pm1p2_svt_lp W=590e-9 L=60e-9 MR=1
MPM0 net11 A VDD VNW pm1p2_svt_lp W=590e-9 L=60e-9 MR=1
.ENDS
.SUBCKT GBUFX2_9TSVT A VDD VSS Y VNW VPW
MNM1 Y net11 VSS VPW nm1p2_svt_lp W=940e-9 L=60e-9 MR=1
MNM0 net11 A VSS VPW nm1p2_svt_lp W=940n L=60n MR=1
MPM1 Y net11 VDD VNW pm1p2_svt_lp W=1.18e-6 L=60e-9 MR=1
MPM0 net11 A VDD VNW pm1p2_svt_lp W=1.18u L=60n MR=1
.ENDS
.SUBCKT GBUFX4_9TSVT A VDD VSS Y VNW VPW
MNM1 Y net11 VSS VPW nm1p2_svt_lp W=1.88e-6 L=60e-9 MR=1
MNM0 net11 A VSS VPW nm1p2_svt_lp W=940e-9 L=60e-9 MR=1
MPM1 Y net11 VDD VNW pm1p2_svt_lp W=2.36e-6 L=60e-9 MR=1
MPM0 net11 A VDD VNW pm1p2_svt_lp W=1.18e-6 L=60e-9 MR=1
.ENDS
.SUBCKT GBUFX8_9TSVT A VDD VSS Y VNW VPW
MNM1 Y net11 VSS VPW nm1p2_svt_lp W=3.76e-6 L=60e-9 MR=1
MNM0 net11 A VSS VPW nm1p2_svt_lp W=1.88e-6 L=60e-9 MR=1
MPM1 Y net11 VDD VNW pm1p2_svt_lp W=4.72e-6 L=60e-9 MR=1
MPM0 net11 A VDD VNW pm1p2_svt_lp W=2.36e-6 L=60e-9 MR=1
.ENDS
.SUBCKT GDFFQX1_9TSVT CK D Q VDD VSS VNW VPW
MNM11 Q net32 VSS VPW nm1p2_svt_lp W=470e-9 L=60e-9 MR=1
MNM9 net38 net32 VSS VPW nm1p2_svt_lp W=470e-9 L=60e-9 MR=1
MNM10 net26 ckn net38 VPW nm1p2_svt_lp W=470e-9 L=60e-9 MR=1
MNM8 net32 net26 VSS VPW nm1p2_svt_lp W=470e-9 L=60e-9 MR=1
MNM7 net26 ckb net23 VPW nm1p2_svt_lp W=470e-9 L=60e-9 MR=1
MNM5 net40 net23 VSS VPW nm1p2_svt_lp W=470e-9 L=60e-9 MR=1
MNM6 net14 ckb net40 VPW nm1p2_svt_lp W=470e-9 L=60e-9 MR=1
MNM4 net23 net14 VSS VPW nm1p2_svt_lp W=470e-9 L=60e-9 MR=1
MNM2 net42 D VSS VPW nm1p2_svt_lp W=470e-9 L=60e-9 MR=1
MNM3 net14 ckn net42 VPW nm1p2_svt_lp W=470e-9 L=60e-9 MR=1
MNM1 ckb ckn VSS VPW nm1p2_svt_lp W=470e-9 L=60e-9 MR=1
MNM0 ckn CK VSS VPW nm1p2_svt_lp W=470e-9 L=60e-9 MR=1
MPM11 Q net32 VDD VNW pm1p2_svt_lp W=590e-9 L=60e-9 MR=1
MPM10 net26 ckb net39 VNW pm1p2_svt_lp W=590e-9 L=60e-9 MR=1
MPM9 net39 net32 VDD VNW pm1p2_svt_lp W=590e-9 L=60e-9 MR=1
MPM8 net32 net26 VDD VNW pm1p2_svt_lp W=590e-9 L=60e-9 MR=1
MPM7 net26 ckn net23 VNW pm1p2_svt_lp W=590e-9 L=60e-9 MR=1
MPM6 net14 ckn net41 VNW pm1p2_svt_lp W=590e-9 L=60e-9 MR=1
MPM5 net41 net23 VDD VNW pm1p2_svt_lp W=590e-9 L=60e-9 MR=1
MPM4 net23 net14 VDD VNW pm1p2_svt_lp W=590e-9 L=60e-9 MR=1
MPM3 net14 ckb net43 VNW pm1p2_svt_lp W=590e-9 L=60e-9 MR=1
MPM2 net43 D VDD VNW pm1p2_svt_lp W=590e-9 L=60e-9 MR=1
MPM1 ckb ckn VDD VNW pm1p2_svt_lp W=590e-9 L=60e-9 MR=1
MPM0 ckn CK VDD VNW pm1p2_svt_lp W=590e-9 L=60e-9 MR=1
.ENDS
.SUBCKT GDFFRNQX1_9TSVT CK D Q RN VDD VSS VNW VPW
MNM11 Q net31 VSS VPW nm1p2_svt_lp W=470e-9 L=60e-9 MR=1
MNM9 net43 net31 VSS VPW nm1p2_svt_lp W=470e-9 L=60e-9 MR=1
MNM10 net28 ckn net43 VPW nm1p2_svt_lp W=470e-9 L=60e-9 MR=1
MNM_RN2 net45 RN VSS VPW nm1p2_svt_lp W=470e-9 L=60e-9 MR=1
MNM8 net31 net28 net45 VPW nm1p2_svt_lp W=470e-9 L=60e-9 MR=1
MNM7 net28 ckb net25 VPW nm1p2_svt_lp W=470e-9 L=60e-9 MR=1
MNM_RN net46 RN VSS VPW nm1p2_svt_lp W=470e-9 L=60e-9 MR=1
MNM5 net47 net25 net46 VPW nm1p2_svt_lp W=470e-9 L=60e-9 MR=1
MNM6 net16 ckb net47 VPW nm1p2_svt_lp W=470e-9 L=60e-9 MR=1
MNM4 net25 net16 VSS VPW nm1p2_svt_lp W=470e-9 L=60e-9 MR=1
MNM2 net48 D VSS VPW nm1p2_svt_lp W=470e-9 L=60e-9 MR=1
MNM3 net16 ckn net48 VPW nm1p2_svt_lp W=470e-9 L=60e-9 MR=1
MNM1 ckb ckn VSS VPW nm1p2_svt_lp W=470e-9 L=60e-9 MR=1
MNM0 ckn CK VSS VPW nm1p2_svt_lp W=470e-9 L=60e-9 MR=1
MPM11 Q net31 VDD VNW pm1p2_svt_lp W=590e-9 L=60e-9 MR=1
MPM10 net28 ckb net44 VNW pm1p2_svt_lp W=590e-9 L=60e-9 MR=1
MPM9 net44 net31 VDD VNW pm1p2_svt_lp W=590e-9 L=60e-9 MR=1
MPM_RN2 net31 RN VDD VNW pm1p2_svt_lp W=590e-9 L=60e-9 MR=1
MPM8 net31 net28 VDD VNW pm1p2_svt_lp W=590e-9 L=60e-9 MR=1
MPM7 net28 ckn net25 VNW pm1p2_svt_lp W=590e-9 L=60e-9 MR=1
MPM6 net16 ckn net38 VNW pm1p2_svt_lp W=590e-9 L=60e-9 MR=1
MPM_RN net38 RN VDD VNW pm1p2_svt_lp W=590e-9 L=60e-9 MR=1
MPM5 net38 net25 VDD VNW pm1p2_svt_lp W=590e-9 L=60e-9 MR=1
MPM4 net25 net16 VDD VNW pm1p2_svt_lp W=590e-9 L=60e-9 MR=1
MPM3 net16 ckb net49 VNW pm1p2_svt_lp W=590e-9 L=60e-9 MR=1
MPM2 net49 D VDD VNW pm1p2_svt_lp W=590e-9 L=60e-9 MR=1
MPM1 ckb ckn VDD VNW pm1p2_svt_lp W=590e-9 L=60e-9 MR=1
MPM0 ckn CK VDD VNW pm1p2_svt_lp W=590e-9 L=60e-9 MR=1
.ENDS
.SUBCKT GDFFSNQX1_9TSVT CK D Q SN VDD VSS VNW VPW
MNM11 Q net33 VSS VPW nm1p2_svt_lp W=470e-9 L=60e-9 MR=1
MNM9 net43 net33 VSS VPW nm1p2_svt_lp W=470e-9 L=60e-9 MR=1
MNM_SN2 net44 SN net43 VPW nm1p2_svt_lp W=470e-9 L=60e-9 MR=1
MNM10 net27 ckn net44 VPW nm1p2_svt_lp W=470e-9 L=60e-9 MR=1
MNM8 net33 net27 VSS VPW nm1p2_svt_lp W=470e-9 L=60e-9 MR=1
MNM7 net27 ckb net22 VPW nm1p2_svt_lp W=470e-9 L=60e-9 MR=1
MNM5 net45 net22 VSS VPW nm1p2_svt_lp W=470e-9 L=60e-9 MR=1
MNM6 net16 ckb net45 VPW nm1p2_svt_lp W=470e-9 L=60e-9 MR=1
MNM4 net47 net16 VSS VPW nm1p2_svt_lp W=470e-9 L=60e-9 MR=1
MNM_SN net22 SN net47 VPW nm1p2_svt_lp W=470e-9 L=60e-9 MR=1
MNM2 net48 D VSS VPW nm1p2_svt_lp W=470e-9 L=60e-9 MR=1
MNM3 net16 ckn net48 VPW nm1p2_svt_lp W=470e-9 L=60e-9 MR=1
MNM1 ckb ckn VSS VPW nm1p2_svt_lp W=470e-9 L=60e-9 MR=1
MNM0 ckn CK VSS VPW nm1p2_svt_lp W=470e-9 L=60e-9 MR=1
MPM11 Q net33 VDD VNW pm1p2_svt_lp W=590e-9 L=60e-9 MR=1
MPM10 net27 ckb net41 VNW pm1p2_svt_lp W=590e-9 L=60e-9 MR=1
MPM_SN2 net41 SN VDD VNW pm1p2_svt_lp W=590e-9 L=60e-9 MR=1
MPM9 net41 net33 VDD VNW pm1p2_svt_lp W=590e-9 L=60e-9 MR=1
MPM8 net33 net27 VDD VNW pm1p2_svt_lp W=590e-9 L=60e-9 MR=1
MPM7 net27 ckn net22 VNW pm1p2_svt_lp W=590e-9 L=60e-9 MR=1
MPM6 net16 ckn net46 VNW pm1p2_svt_lp W=590e-9 L=60e-9 MR=1
MPM5 net46 net22 VDD VNW pm1p2_svt_lp W=590e-9 L=60e-9 MR=1
MPM_SN net22 SN VDD VNW pm1p2_svt_lp W=590e-9 L=60e-9 MR=1
MPM4 net22 net16 VDD VNW pm1p2_svt_lp W=590e-9 L=60e-9 MR=1
MPM3 net16 ckb net49 VNW pm1p2_svt_lp W=590e-9 L=60e-9 MR=1
MPM2 net49 D VDD VNW pm1p2_svt_lp W=590e-9 L=60e-9 MR=1
MPM1 ckb ckn VDD VNW pm1p2_svt_lp W=590e-9 L=60e-9 MR=1
MPM0 ckn CK VDD VNW pm1p2_svt_lp W=590e-9 L=60e-9 MR=1
.ENDS
.SUBCKT GFILL16_9TSVT VDD VSS VNW VPW
MPM7 net17 Y net17 VNW pm1p2_svt_lp W=590e-9 L=60e-9 MR=1
MPM6 Y A net17 VNW pm1p2_svt_lp W=590e-9 L=60e-9 MR=1
MPM5 net13 Y net13 VNW pm1p2_svt_lp W=590e-9 L=60e-9 MR=1
MPM4 Y A net13 VNW pm1p2_svt_lp W=590e-9 L=60e-9 MR=1
MPM3 net9 Y net9 VNW pm1p2_svt_lp W=590e-9 L=60e-9 MR=1
MPM2 Y A net9 VNW pm1p2_svt_lp W=590e-9 L=60e-9 MR=1
MPM1 net5 Y net5 VNW pm1p2_svt_lp W=590e-9 L=60e-9 MR=1
MPM0 Y A net5 VNW pm1p2_svt_lp W=590e-9 L=60e-9 MR=1
MNM7 net16 A net16 VPW nm1p2_svt_lp W=470e-9 L=60e-9 MR=1
MNM6 A Y net16 VPW nm1p2_svt_lp W=470e-9 L=60e-9 MR=1
MNM5 net12 A net12 VPW nm1p2_svt_lp W=470e-9 L=60e-9 MR=1
MNM4 A Y net12 VPW nm1p2_svt_lp W=470e-9 L=60e-9 MR=1
MNM3 net8 A net8 VPW nm1p2_svt_lp W=470e-9 L=60e-9 MR=1
MNM2 A Y net8 VPW nm1p2_svt_lp W=470e-9 L=60e-9 MR=1
MNM1 net4 A net4 VPW nm1p2_svt_lp W=470e-9 L=60e-9 MR=1
MNM0 A Y net4 VPW nm1p2_svt_lp W=470e-9 L=60e-9 MR=1
.ENDS
.SUBCKT GFILL32_9TSVT VDD VSS VNW VPW
MPM15 net33 Y net33 VNW pm1p2_svt_lp W=590e-9 L=60e-9 MR=1
MPM14 Y A net33 VNW pm1p2_svt_lp W=590e-9 L=60e-9 MR=1
MPM13 net29 Y net29 VNW pm1p2_svt_lp W=590e-9 L=60e-9 MR=1
MPM12 Y A net29 VNW pm1p2_svt_lp W=590e-9 L=60e-9 MR=1
MPM11 net25 Y net25 VNW pm1p2_svt_lp W=590e-9 L=60e-9 MR=1
MPM10 Y A net25 VNW pm1p2_svt_lp W=590e-9 L=60e-9 MR=1
MPM9 net21 Y net21 VNW pm1p2_svt_lp W=590e-9 L=60e-9 MR=1
MPM8 Y A net21 VNW pm1p2_svt_lp W=590e-9 L=60e-9 MR=1
MPM7 net17 Y net17 VNW pm1p2_svt_lp W=590e-9 L=60e-9 MR=1
MPM6 Y A net17 VNW pm1p2_svt_lp W=590e-9 L=60e-9 MR=1
MPM5 net13 Y net13 VNW pm1p2_svt_lp W=590e-9 L=60e-9 MR=1
MPM4 Y A net13 VNW pm1p2_svt_lp W=590e-9 L=60e-9 MR=1
MPM3 net9 Y net9 VNW pm1p2_svt_lp W=590e-9 L=60e-9 MR=1
MPM2 Y A net9 VNW pm1p2_svt_lp W=590e-9 L=60e-9 MR=1
MPM1 net5 Y net5 VNW pm1p2_svt_lp W=590e-9 L=60e-9 MR=1
MPM0 Y A net5 VNW pm1p2_svt_lp W=590e-9 L=60e-9 MR=1
MNM15 net32 A net32 VPW nm1p2_svt_lp W=470e-9 L=60e-9 MR=1
MNM14 A Y net32 VPW nm1p2_svt_lp W=470e-9 L=60e-9 MR=1
MNM13 net28 A net28 VPW nm1p2_svt_lp W=470e-9 L=60e-9 MR=1
MNM12 A Y net28 VPW nm1p2_svt_lp W=470e-9 L=60e-9 MR=1
MNM11 net24 A net24 VPW nm1p2_svt_lp W=470e-9 L=60e-9 MR=1
MNM10 A Y net24 VPW nm1p2_svt_lp W=470e-9 L=60e-9 MR=1
MNM9 net20 A net20 VPW nm1p2_svt_lp W=470e-9 L=60e-9 MR=1
MNM8 A Y net20 VPW nm1p2_svt_lp W=470e-9 L=60e-9 MR=1
MNM7 net16 A net16 VPW nm1p2_svt_lp W=470e-9 L=60e-9 MR=1
MNM6 A Y net16 VPW nm1p2_svt_lp W=470e-9 L=60e-9 MR=1
MNM5 net12 A net12 VPW nm1p2_svt_lp W=470e-9 L=60e-9 MR=1
MNM4 A Y net12 VPW nm1p2_svt_lp W=470e-9 L=60e-9 MR=1
MNM3 net8 A net8 VPW nm1p2_svt_lp W=470e-9 L=60e-9 MR=1
MNM2 A Y net8 VPW nm1p2_svt_lp W=470e-9 L=60e-9 MR=1
MNM1 net4 A net4 VPW nm1p2_svt_lp W=470e-9 L=60e-9 MR=1
MNM0 A Y net4 VPW nm1p2_svt_lp W=470e-9 L=60e-9 MR=1
.ENDS
.SUBCKT GFILL4_9TSVT VDD VSS VNW VPW
MPM1 net5 Y net5 VNW pm1p2_svt_lp W=590e-9 L=60e-9 MR=1
MPM0 Y A net5 VNW pm1p2_svt_lp W=590e-9 L=60e-9 MR=1
MNM1 net4 A net4 VPW nm1p2_svt_lp W=470e-9 L=60e-9 MR=1
MNM0 A Y net4 VPW nm1p2_svt_lp W=470e-9 L=60e-9 MR=1
.ENDS
.SUBCKT GFILL8_9TSVT VDD VSS VNW VPW
MPM3 net9 Y net9 VNW pm1p2_svt_lp W=590e-9 L=60e-9 MR=1
MPM2 Y A net9 VNW pm1p2_svt_lp W=590e-9 L=60e-9 MR=1
MPM1 net5 Y net5 VNW pm1p2_svt_lp W=590e-9 L=60e-9 MR=1
MPM0 Y A net5 VNW pm1p2_svt_lp W=590e-9 L=60e-9 MR=1
MNM3 net8 A net8 VPW nm1p2_svt_lp W=470e-9 L=60e-9 MR=1
MNM2 A Y net8 VPW nm1p2_svt_lp W=470e-9 L=60e-9 MR=1
MNM1 net4 A net4 VPW nm1p2_svt_lp W=470e-9 L=60e-9 MR=1
MNM0 A Y net4 VPW nm1p2_svt_lp W=470e-9 L=60e-9 MR=1
.ENDS
.SUBCKT GFILLCAP16_9TSVT VDD VSS VNW VPW
MPM1 VDD net7 VDD VNW pm1p2_svt_lp W=2.36e-6 L=60e-9 MR=1
MPM0 net7 net3 VDD VNW pm1p2_svt_lp W=2.36e-6 L=60e-9 MR=1
MNM1 VSS net3 VSS VPW nm1p2_svt_lp W=1.88e-6 L=60e-9 MR=1
MNM0 net3 net7 VSS VPW nm1p2_svt_lp W=1.88e-6 L=60e-9 MR=1
.ENDS
.SUBCKT GFILLCAP32_9TSVT VDD VSS VNW VPW
MPM1 VDD net7 VDD VNW pm1p2_svt_lp W=4.72e-6 L=60e-9 MR=1
MPM0 net7 net3 VDD VNW pm1p2_svt_lp W=4.72e-6 L=60e-9 MR=1
MNM1 VSS net3 VSS VPW nm1p2_svt_lp W=3.76e-6 L=60e-9 MR=1
MNM0 net3 net7 VSS VPW nm1p2_svt_lp W=3.76e-6 L=60e-9 MR=1
.ENDS
.SUBCKT GFILLCAP4_9TSVT VDD VSS VNW VPW
MPM1 VDD net7 VDD VNW pm1p2_svt_lp W=590e-9 L=60e-9 MR=1
MPM0 net7 net3 VDD VNW pm1p2_svt_lp W=590e-9 L=60e-9 MR=1
MNM1 VSS net3 VSS VPW nm1p2_svt_lp W=470e-9 L=60e-9 MR=1
MNM0 net3 net7 VSS VPW nm1p2_svt_lp W=470e-9 L=60e-9 MR=1
.ENDS
.SUBCKT GFILLCAP8_9TSVT VDD VSS VNW VPW
MPM1 VDD net7 VDD VNW pm1p2_svt_lp W=1.18e-6 L=60e-9 MR=1
MPM0 net7 net3 VDD VNW pm1p2_svt_lp W=1.18e-6 L=60e-9 MR=1
MNM1 VSS net3 VSS VPW nm1p2_svt_lp W=940e-9 L=60e-9 MR=1
MNM0 net3 net7 VSS VPW nm1p2_svt_lp W=940e-9 L=60e-9 MR=1
.ENDS
.SUBCKT GINVX1_9TSVT A VDD VSS Y VNW VPW
MM0 VSS A VSS VPW nm1p2_svt_lp W=470e-9 L=60e-9 MR=1
MNM0 Y A VSS VPW nm1p2_svt_lp W=470e-9 L=60e-9 MR=1
MM1 VDD A VDD VNW pm1p2_svt_lp W=590e-9 L=60e-9 MR=1
MPM0 Y A VDD VNW pm1p2_svt_lp W=590e-9 L=60e-9 MR=1
.ENDS
.SUBCKT GINVX2_9TSVT A VDD VSS Y VNW VPW
MNM0 Y A VSS VPW nm1p2_svt_lp W=940e-9 L=60e-9 MR=1
MPM0 Y A VDD VNW pm1p2_svt_lp W=1.18e-6 L=60e-9 MR=1
.ENDS
.SUBCKT GINVX4_9TSVT A VDD VSS Y VNW VPW
MNM0 Y A VSS VPW nm1p2_svt_lp W=1.88e-6 L=60e-9 MR=1
MPM0 Y A VDD VNW pm1p2_svt_lp W=2.36e-6 L=60e-9 MR=1
.ENDS
.SUBCKT GINVX8_9TSVT A VDD VSS Y VNW VPW
MNM0 Y A VSS VPW nm1p2_svt_lp W=3.76e-6 L=60e-9 MR=1
MPM0 Y A VDD VNW pm1p2_svt_lp W=4.72e-6 L=60e-9 MR=1
.ENDS
.SUBCKT GLATQX1_9TSVT CK D Q VDD VSS VNW VPW
MNM8 Q net26 VSS VPW nm1p2_svt_lp W=940n L=60n MR=1
MNM7 net26 net23 VSS VPW nm1p2_svt_lp W=470e-9 L=60e-9 MR=1
MNM5 net31 net23 VSS VPW nm1p2_svt_lp W=470e-9 L=60e-9 MR=1
MNM6 net17 ckn net31 VPW nm1p2_svt_lp W=470e-9 L=60e-9 MR=1
MNM4 net23 net17 VSS VPW nm1p2_svt_lp W=470e-9 L=60e-9 MR=1
MNM2 net33 D VSS VPW nm1p2_svt_lp W=470e-9 L=60e-9 MR=1
MNM3 net17 ckb net33 VPW nm1p2_svt_lp W=470e-9 L=60e-9 MR=1
MNM1 ckb ckn VSS VPW nm1p2_svt_lp W=470e-9 L=60e-9 MR=1
MNM0 ckn CK VSS VPW nm1p2_svt_lp W=470e-9 L=60e-9 MR=1
MPM8 Q net26 VDD VNW pm1p2_svt_lp W=1.18u L=60n MR=1
MPM7 net26 net23 VDD VNW pm1p2_svt_lp W=590e-9 L=60e-9 MR=1
MPM6 net17 ckb net32 VNW pm1p2_svt_lp W=590e-9 L=60e-9 MR=1
MPM5 net32 net23 VDD VNW pm1p2_svt_lp W=590e-9 L=60e-9 MR=1
MPM4 net23 net17 VDD VNW pm1p2_svt_lp W=590e-9 L=60e-9 MR=1
MPM3 net17 ckn net34 VNW pm1p2_svt_lp W=590e-9 L=60e-9 MR=1
MPM2 net34 D VDD VNW pm1p2_svt_lp W=590e-9 L=60e-9 MR=1
MPM1 ckb ckn VDD VNW pm1p2_svt_lp W=590e-9 L=60e-9 MR=1
MPM0 ckn CK VDD VNW pm1p2_svt_lp W=590e-9 L=60e-9 MR=1
.ENDS
.SUBCKT GLATRNQX1_9TSVT CK D Q RN VDD VSS VNW VPW
MNM8 Q net27 VSS VPW nm1p2_svt_lp W=940n L=60n MR=1
MNM7 net27 net24 VSS VPW nm1p2_svt_lp W=470e-9 L=60e-9 MR=1
MNM_RN net34 RN VSS VPW nm1p2_svt_lp W=470e-9 L=60e-9 MR=1
MNM5 net35 net24 net34 VPW nm1p2_svt_lp W=470e-9 L=60e-9 MR=1
MNM6 net15 ckn net35 VPW nm1p2_svt_lp W=470e-9 L=60e-9 MR=1
MNM4 net24 net15 VSS VPW nm1p2_svt_lp W=470e-9 L=60e-9 MR=1
MNM0_RN net36 RN VSS VPW nm1p2_svt_lp W=470e-9 L=60e-9 MR=1
MNM2 net37 D net36 VPW nm1p2_svt_lp W=470e-9 L=60e-9 MR=1
MNM3 net15 ckb net37 VPW nm1p2_svt_lp W=470e-9 L=60e-9 MR=1
MNM1 ckb ckn VSS VPW nm1p2_svt_lp W=470e-9 L=60e-9 MR=1
MNM0 ckn CK VSS VPW nm1p2_svt_lp W=470e-9 L=60e-9 MR=1
MPM8 Q net27 VDD VNW pm1p2_svt_lp W=1.18u L=60n MR=1
MPM7 net27 net24 VDD VNW pm1p2_svt_lp W=590e-9 L=60e-9 MR=1
MPM6 net15 ckb net32 VNW pm1p2_svt_lp W=590e-9 L=60e-9 MR=1
MPM_RN net32 RN VDD VNW pm1p2_svt_lp W=590e-9 L=60e-9 MR=1
MPM5 net32 net24 VDD VNW pm1p2_svt_lp W=590e-9 L=60e-9 MR=1
MPM4 net24 net15 VDD VNW pm1p2_svt_lp W=590e-9 L=60e-9 MR=1
MPM3 net15 ckn net38 VNW pm1p2_svt_lp W=590e-9 L=60e-9 MR=1
MPM0_RN net15 RN VDD VNW pm1p2_svt_lp W=590e-9 L=60e-9 MR=1
MPM2 net38 D VDD VNW pm1p2_svt_lp W=590e-9 L=60e-9 MR=1
MPM1 ckb ckn VDD VNW pm1p2_svt_lp W=590e-9 L=60e-9 MR=1
MPM0 ckn CK VDD VNW pm1p2_svt_lp W=590e-9 L=60e-9 MR=1
.ENDS
.SUBCKT GLATSNQX1_9TSVT CK D Q SN VDD VSS VNW VPW
MNM8 Q net27 VSS VPW nm1p2_svt_lp W=470e-9 L=60e-9 MR=1
MNM7 net27 net22 VSS VPW nm1p2_svt_lp W=470e-9 L=60e-9 MR=1
MNM5 net34 net22 VSS VPW nm1p2_svt_lp W=470e-9 L=60e-9 MR=1
MNM6 net19 ckn net34 VPW nm1p2_svt_lp W=470e-9 L=60e-9 MR=1
MNM4 net36 net19 VSS VPW nm1p2_svt_lp W=470e-9 L=60e-9 MR=1
MNM_SN net22 SN net36 VPW nm1p2_svt_lp W=470e-9 L=60e-9 MR=1
MNM2 net37 D VSS VPW nm1p2_svt_lp W=470e-9 L=60e-9 MR=1
MNM3 net19 ckb net37 VPW nm1p2_svt_lp W=470e-9 L=60e-9 MR=1
MNM1 ckb ckn VSS VPW nm1p2_svt_lp W=470e-9 L=60e-9 MR=1
MNM0 ckn CK VSS VPW nm1p2_svt_lp W=470e-9 L=60e-9 MR=1
MPM8 Q net27 VDD VNW pm1p2_svt_lp W=590e-9 L=60e-9 MR=1
MPM7 net27 net22 VDD VNW pm1p2_svt_lp W=590e-9 L=60e-9 MR=1
MPM6 net19 ckb net35 VNW pm1p2_svt_lp W=590e-9 L=60e-9 MR=1
MPM5 net35 net22 VDD VNW pm1p2_svt_lp W=590e-9 L=60e-9 MR=1
MPM_SN net22 SN VDD VNW pm1p2_svt_lp W=590e-9 L=60e-9 MR=1
MPM4 net22 net19 VDD VNW pm1p2_svt_lp W=590e-9 L=60e-9 MR=1
MPM3 net19 ckn net38 VNW pm1p2_svt_lp W=590e-9 L=60e-9 MR=1
MPM2 net38 D VDD VNW pm1p2_svt_lp W=590e-9 L=60e-9 MR=1
MPM1 ckb ckn VDD VNW pm1p2_svt_lp W=590e-9 L=60e-9 MR=1
MPM0 ckn CK VDD VNW pm1p2_svt_lp W=590e-9 L=60e-9 MR=1
.ENDS
.SUBCKT GMX2X1_9TSVT A B S VDD VSS Y VNW VPW
MNM5 SN S VSS VPW nm1p2_svt_lp W=470e-9 L=60e-9 MR=1
MNM4 Y net23 VSS VPW nm1p2_svt_lp W=470e-9 L=60e-9 MR=1
MNM3 net23 S net15 VPW nm1p2_svt_lp W=470e-9 L=60e-9 MR=1
MNM2 net23 SN net17 VPW nm1p2_svt_lp W=470e-9 L=60e-9 MR=1
MNM1 net15 B VSS VPW nm1p2_svt_lp W=470e-9 L=60e-9 MR=1
MNM0 net17 A VSS VPW nm1p2_svt_lp W=470e-9 L=60e-9 MR=1
MPM5 SN S VDD VNW pm1p2_svt_lp W=590e-9 L=60e-9 MR=1
MPM4 Y net23 VDD VNW pm1p2_svt_lp W=590e-9 L=60e-9 MR=1
MPM3 net23 SN net15 VNW pm1p2_svt_lp W=590e-9 L=60e-9 MR=1
MPM2 net23 S net17 VNW pm1p2_svt_lp W=590e-9 L=60e-9 MR=1
MPM1 net15 B VDD VNW pm1p2_svt_lp W=590e-9 L=60e-9 MR=1
MPM0 net17 A VDD VNW pm1p2_svt_lp W=590e-9 L=60e-9 MR=1
.ENDS
.SUBCKT GMX2X2_9TSVT A B S VDD VSS Y VNW VPW
MNM5 SN S VSS VPW nm1p2_svt_lp W=470e-9 L=60e-9 MR=1
MNM4 Y net23 VSS VPW nm1p2_svt_lp W=940e-9 L=60e-9 MR=1
MNM3 net23 S net15 VPW nm1p2_svt_lp W=470e-9 L=60e-9 MR=1
MNM2 net23 SN net17 VPW nm1p2_svt_lp W=470e-9 L=60e-9 MR=1
MNM1 net15 B VSS VPW nm1p2_svt_lp W=470e-9 L=60e-9 MR=1
MNM0 net17 A VSS VPW nm1p2_svt_lp W=940n L=60n MR=1
MPM5 SN S VDD VNW pm1p2_svt_lp W=590e-9 L=60e-9 MR=1
MPM4 Y net23 VDD VNW pm1p2_svt_lp W=1.18e-6 L=60e-9 MR=1
MPM3 net23 SN net15 VNW pm1p2_svt_lp W=590e-9 L=60e-9 MR=1
MPM2 net23 S net17 VNW pm1p2_svt_lp W=590e-9 L=60e-9 MR=1
MPM1 net15 B VDD VNW pm1p2_svt_lp W=590e-9 L=60e-9 MR=1
MPM0 net17 A VDD VNW pm1p2_svt_lp W=1.18u L=60n MR=1
.ENDS
.SUBCKT GMXI2X1_9TSVT A B S VDD VSS Y VNW VPW
MNM6 SN S VSS VPW nm1p2_svt_lp W=470e-9 L=60e-9 MR=1
MNM5 Y net27 VSS VPW nm1p2_svt_lp W=470e-9 L=60e-9 MR=1
MNM4 net27 net23 VSS VPW nm1p2_svt_lp W=470e-9 L=60e-9 MR=1
MNM3 net23 S net15 VPW nm1p2_svt_lp W=470e-9 L=60e-9 MR=1
MNM2 net23 SN net17 VPW nm1p2_svt_lp W=470e-9 L=60e-9 MR=1
MNM1 net15 B VSS VPW nm1p2_svt_lp W=470e-9 L=60e-9 MR=1
MNM0 net17 A VSS VPW nm1p2_svt_lp W=940n L=60n MR=1
MPM6 SN S VDD VNW pm1p2_svt_lp W=590e-9 L=60e-9 MR=1
MPM5 Y net27 VDD VNW pm1p2_svt_lp W=590e-9 L=60e-9 MR=1
MPM4 net27 net23 VDD VNW pm1p2_svt_lp W=590e-9 L=60e-9 MR=1
MPM3 net23 SN net15 VNW pm1p2_svt_lp W=590e-9 L=60e-9 MR=1
MPM2 net23 S net17 VNW pm1p2_svt_lp W=590e-9 L=60e-9 MR=1
MPM1 net15 B VDD VNW pm1p2_svt_lp W=590e-9 L=60e-9 MR=1
MPM0 net17 A VDD VNW pm1p2_svt_lp W=1.18u L=60n MR=1
.ENDS
.SUBCKT GMXI2X2_9TSVT A B S VDD VSS Y VNW VPW
MNM6 SN S VSS VPW nm1p2_svt_lp W=470e-9 L=60e-9 MR=1
MNM5 Y net27 VSS VPW nm1p2_svt_lp W=940e-9 L=60e-9 MR=1
MNM4 net27 net23 VSS VPW nm1p2_svt_lp W=470e-9 L=60e-9 MR=1
MNM3 net23 S net15 VPW nm1p2_svt_lp W=470e-9 L=60e-9 MR=1
MNM2 net23 SN net17 VPW nm1p2_svt_lp W=470e-9 L=60e-9 MR=1
MNM1 net15 B VSS VPW nm1p2_svt_lp W=470e-9 L=60e-9 MR=1
MNM0 net17 A VSS VPW nm1p2_svt_lp W=470e-9 L=60e-9 MR=1
MPM6 SN S VDD VNW pm1p2_svt_lp W=590e-9 L=60e-9 MR=1
MPM5 Y net27 VDD VNW pm1p2_svt_lp W=1.18e-6 L=60e-9 MR=1
MPM4 net27 net23 VDD VNW pm1p2_svt_lp W=590e-9 L=60e-9 MR=1
MPM3 net23 SN net15 VNW pm1p2_svt_lp W=590e-9 L=60e-9 MR=1
MPM2 net23 S net17 VNW pm1p2_svt_lp W=590e-9 L=60e-9 MR=1
MPM1 net15 B VDD VNW pm1p2_svt_lp W=590e-9 L=60e-9 MR=1
MPM0 net17 A VDD VNW pm1p2_svt_lp W=590e-9 L=60e-9 MR=1
.ENDS
.SUBCKT GNAND2X1_9TSVT A B VDD VSS Y VNW VPW
MNM1 net15 B VSS VPW nm1p2_svt_lp W=470e-9 L=60e-9 MR=1
MNM0 Y A net15 VPW nm1p2_svt_lp W=470e-9 L=60e-9 MR=1
MPM1 Y B VDD VNW pm1p2_svt_lp W=590e-9 L=60e-9 MR=1
MPM0 Y A VDD VNW pm1p2_svt_lp W=590e-9 L=60e-9 MR=1
.ENDS
.SUBCKT GNAND2X2_9TSVT A B VDD VSS Y VNW VPW
MNM1 net15 B VSS VPW nm1p2_svt_lp W=940e-9 L=60e-9 MR=1
MNM0 Y A net15 VPW nm1p2_svt_lp W=940e-9 L=60e-9 MR=1
MPM1 Y B VDD VNW pm1p2_svt_lp W=1.18e-6 L=60e-9 MR=1
MPM0 Y A VDD VNW pm1p2_svt_lp W=1.18e-6 L=60e-9 MR=1
.ENDS
.SUBCKT GNAND2X4_9TSVT A B VDD VSS Y VNW VPW
MNM1 net15 B VSS VPW nm1p2_svt_lp W=1.88e-6 L=60e-9 MR=1
MNM0 Y A net15 VPW nm1p2_svt_lp W=1.88e-6 L=60e-9 MR=1
MPM1 Y B VDD VNW pm1p2_svt_lp W=2.36e-6 L=60e-9 MR=1
MPM0 Y A VDD VNW pm1p2_svt_lp W=2.36e-6 L=60e-9 MR=1
.ENDS
.SUBCKT GNAND3X1_9TSVT A B C VDD VSS Y VNW VPW
MNM2 net20 C VSS VPW nm1p2_svt_lp W=940n L=60n MR=1
MNM1 net21 B net20 VPW nm1p2_svt_lp W=470e-9 L=60e-9 MR=1
MNM0 Y A net21 VPW nm1p2_svt_lp W=470e-9 L=60e-9 MR=1
MPM2 Y C VDD VNW pm1p2_svt_lp W=1.18u L=60n MR=1
MPM1 Y B VDD VNW pm1p2_svt_lp W=590e-9 L=60e-9 MR=1
MPM0 Y A VDD VNW pm1p2_svt_lp W=590e-9 L=60e-9 MR=1
.ENDS
.SUBCKT GNAND3X2_9TSVT A B C VDD VSS Y VNW VPW
MNM2 net20 C VSS VPW nm1p2_svt_lp W=940e-9 L=60e-9 MR=1
MNM1 net21 B net20 VPW nm1p2_svt_lp W=940e-9 L=60e-9 MR=1
MNM0 Y A net21 VPW nm1p2_svt_lp W=940e-9 L=60e-9 MR=1
MPM2 Y C VDD VNW pm1p2_svt_lp W=1.18e-6 L=60e-9 MR=1
MPM1 Y B VDD VNW pm1p2_svt_lp W=1.18e-6 L=60e-9 MR=1
MPM0 Y A VDD VNW pm1p2_svt_lp W=1.18e-6 L=60e-9 MR=1
.ENDS
.SUBCKT GNAND3X4_9TSVT A B C VDD VSS Y VNW VPW
MNM2 net20 C VSS VPW nm1p2_svt_lp W=1.88e-6 L=60e-9 MR=1
MNM1 net21 B net20 VPW nm1p2_svt_lp W=1.88e-6 L=60e-9 MR=1
MNM0 Y A net21 VPW nm1p2_svt_lp W=1.88e-6 L=60e-9 MR=1
MPM2 Y C VDD VNW pm1p2_svt_lp W=2.36e-6 L=60e-9 MR=1
MPM1 Y B VDD VNW pm1p2_svt_lp W=2.36e-6 L=60e-9 MR=1
MPM0 Y A VDD VNW pm1p2_svt_lp W=2.36e-6 L=60e-9 MR=1
.ENDS
.SUBCKT GNOR2X1_9TSVT A B VDD VSS Y VNW VPW
MPM1 net15 B VDD VNW pm1p2_svt_lp W=590e-9 L=60e-9 MR=1
MPM0 Y A net15 VNW pm1p2_svt_lp W=590e-9 L=60e-9 MR=1
MNM1 Y B VSS VPW nm1p2_svt_lp W=470e-9 L=60e-9 MR=1
MNM0 Y A VSS VPW nm1p2_svt_lp W=470e-9 L=60e-9 MR=1
.ENDS
.SUBCKT GNOR2X2_9TSVT A B VDD VSS Y VNW VPW
MPM1 net15 B VDD VNW pm1p2_svt_lp W=1.18e-6 L=60e-9 MR=1
MPM0 Y A net15 VNW pm1p2_svt_lp W=1.18e-6 L=60e-9 MR=1
MNM1 Y B VSS VPW nm1p2_svt_lp W=940e-9 L=60e-9 MR=1
MNM0 Y A VSS VPW nm1p2_svt_lp W=940e-9 L=60e-9 MR=1
.ENDS
.SUBCKT GNOR2X4_9TSVT A B VDD VSS Y VNW VPW
MPM1 net15 B VDD VNW pm1p2_svt_lp W=2.36e-6 L=60e-9 MR=1
MPM0 Y A net15 VNW pm1p2_svt_lp W=2.36e-6 L=60e-9 MR=1
MNM1 Y B VSS VPW nm1p2_svt_lp W=1.88e-6 L=60e-9 MR=1
MNM0 Y A VSS VPW nm1p2_svt_lp W=1.88e-6 L=60e-9 MR=1
.ENDS
.SUBCKT GNOR3X1_9TSVT A B C VDD VSS Y VNW VPW
MPM2 net19 C VDD VNW pm1p2_svt_lp W=1.18u L=60n MR=1
MPM1 net20 B net19 VNW pm1p2_svt_lp W=590e-9 L=60e-9 MR=1
MPM0 Y A net20 VNW pm1p2_svt_lp W=590e-9 L=60e-9 MR=1
MNM2 Y C VSS VPW nm1p2_svt_lp W=940n L=60n MR=1
MNM1 Y B VSS VPW nm1p2_svt_lp W=470e-9 L=60e-9 MR=1
MNM0 Y A VSS VPW nm1p2_svt_lp W=470e-9 L=60e-9 MR=1
.ENDS
.SUBCKT GNOR3X2_9TSVT A B C VDD VSS Y VNW VPW
MPM2 net19 C VDD VNW pm1p2_svt_lp W=1.18e-6 L=60e-9 MR=1
MPM1 net20 B net19 VNW pm1p2_svt_lp W=1.18e-6 L=60e-9 MR=1
MPM0 Y A net20 VNW pm1p2_svt_lp W=1.18e-6 L=60e-9 MR=1
MNM2 Y C VSS VPW nm1p2_svt_lp W=940e-9 L=60e-9 MR=1
MNM1 Y B VSS VPW nm1p2_svt_lp W=940e-9 L=60e-9 MR=1
MNM0 Y A VSS VPW nm1p2_svt_lp W=940e-9 L=60e-9 MR=1
.ENDS
.SUBCKT GNOR3X4_9TSVT A B C VDD VSS Y VNW VPW
MPM2 net19 C VDD VNW pm1p2_svt_lp W=2.36e-6 L=60e-9 MR=1
MPM1 net20 B net19 VNW pm1p2_svt_lp W=2.36e-6 L=60e-9 MR=1
MPM0 Y A net20 VNW pm1p2_svt_lp W=2.36e-6 L=60e-9 MR=1
MNM2 Y C VSS VPW nm1p2_svt_lp W=1.88e-6 L=60e-9 MR=1
MNM1 Y B VSS VPW nm1p2_svt_lp W=1.88e-6 L=60e-9 MR=1
MNM0 Y A VSS VPW nm1p2_svt_lp W=1.88e-6 L=60e-9 MR=1
.ENDS
.SUBCKT GOAI21X1_9TSVT A0 A1 B0 VDD VSS Y VNW VPW
MM0 VSS B0 VSS VPW nm1p2_svt_lp W=470e-9 L=60e-9 MR=1
MNM2 net13 B0 VSS VPW nm1p2_svt_lp W=470e-9 L=60e-9 MR=1
MNM1 Y A1 net13 VPW nm1p2_svt_lp W=470e-9 L=60e-9 MR=1
MNM0 Y A0 net13 VPW nm1p2_svt_lp W=470e-9 L=60e-9 MR=1
MM1 VDD B0 VDD VNW pm1p2_svt_lp W=590e-9 L=60e-9 MR=1
MPM2 Y B0 VDD VNW pm1p2_svt_lp W=590e-9 L=60e-9 MR=1
MPM1 net19 A1 VDD VNW pm1p2_svt_lp W=590e-9 L=60e-9 MR=1
MPM0 Y A0 net19 VNW pm1p2_svt_lp W=590e-9 L=60e-9 MR=1
.ENDS
.SUBCKT GOAI21X2_9TSVT A0 A1 B0 VDD VSS Y VNW VPW
MNM2 net13 B0 VSS VPW nm1p2_svt_lp W=940e-9 L=60e-9 MR=1
MNM1 Y A1 net13 VPW nm1p2_svt_lp W=940e-9 L=60e-9 MR=1
MNM0 Y A0 net13 VPW nm1p2_svt_lp W=940e-9 L=60e-9 MR=1
MPM2 Y B0 VDD VNW pm1p2_svt_lp W=1.18e-6 L=60e-9 MR=1
MPM1 net19 A1 VDD VNW pm1p2_svt_lp W=1.18e-6 L=60e-9 MR=1
MPM0 Y A0 net19 VNW pm1p2_svt_lp W=1.18e-6 L=60e-9 MR=1
.ENDS
.SUBCKT GOAI22X1_9TSVT A0 A1 B0 B1 VDD VSS Y VNW VPW
MNM3 net15 B1 VSS VPW nm1p2_svt_lp W=470e-9 L=60e-9 MR=1
MNM2 net15 B0 VSS VPW nm1p2_svt_lp W=470e-9 L=60e-9 MR=1
MNM1 Y A1 net15 VPW nm1p2_svt_lp W=470e-9 L=60e-9 MR=1
MNM0 Y A0 net15 VPW nm1p2_svt_lp W=470e-9 L=60e-9 MR=1
MPM3 net22 B1 VDD VNW pm1p2_svt_lp W=590e-9 L=60e-9 MR=1
MPM2 Y B0 net22 VNW pm1p2_svt_lp W=590e-9 L=60e-9 MR=1
MPM1 net23 A1 VDD VNW pm1p2_svt_lp W=590e-9 L=60e-9 MR=1
MPM0 Y A0 net23 VNW pm1p2_svt_lp W=590e-9 L=60e-9 MR=1
.ENDS
.SUBCKT GOAI22X2_9TSVT A0 A1 B0 B1 VDD VSS Y VNW VPW
MNM3 net15 B1 VSS VPW nm1p2_svt_lp W=940e-9 L=60e-9 MR=1
MNM2 net15 B0 VSS VPW nm1p2_svt_lp W=940e-9 L=60e-9 MR=1
MNM1 Y A1 net15 VPW nm1p2_svt_lp W=940e-9 L=60e-9 MR=1
MNM0 Y A0 net15 VPW nm1p2_svt_lp W=940e-9 L=60e-9 MR=1
MPM3 net22 B1 VDD VNW pm1p2_svt_lp W=1.18e-6 L=60e-9 MR=1
MPM2 Y B0 net22 VNW pm1p2_svt_lp W=1.18e-6 L=60e-9 MR=1
MPM1 net23 A1 VDD VNW pm1p2_svt_lp W=1.18e-6 L=60e-9 MR=1
MPM0 Y A0 net23 VNW pm1p2_svt_lp W=1.18e-6 L=60e-9 MR=1
.ENDS
.SUBCKT GOAI31X1_9TSVT A0 A1 A2 B0 VDD VSS Y VNW VPW
MNM3 net15 B0 VSS VPW nm1p2_svt_lp W=470e-9 L=60e-9 MR=1
MNM2 Y A2 net15 VPW nm1p2_svt_lp W=470e-9 L=60e-9 MR=1
MNM1 Y A1 net15 VPW nm1p2_svt_lp W=470e-9 L=60e-9 MR=1
MNM0 Y A0 net15 VPW nm1p2_svt_lp W=470e-9 L=60e-9 MR=1
MPM3 Y B0 VDD VNW pm1p2_svt_lp W=590e-9 L=60e-9 MR=1
MPM2 net23 A2 VDD VNW pm1p2_svt_lp W=590e-9 L=60e-9 MR=1
MPM1 net24 A1 net23 VNW pm1p2_svt_lp W=590e-9 L=60e-9 MR=1
MPM0 Y A0 net24 VNW pm1p2_svt_lp W=590e-9 L=60e-9 MR=1
.ENDS
.SUBCKT GOAI31X2_9TSVT A0 A1 A2 B0 VDD VSS Y VNW VPW
MNM3 net15 B0 VSS VPW nm1p2_svt_lp W=940e-9 L=60e-9 MR=1
MNM2 Y A2 net15 VPW nm1p2_svt_lp W=940e-9 L=60e-9 MR=1
MNM1 Y A1 net15 VPW nm1p2_svt_lp W=940e-9 L=60e-9 MR=1
MNM0 Y A0 net15 VPW nm1p2_svt_lp W=940e-9 L=60e-9 MR=1
MPM3 Y B0 VDD VNW pm1p2_svt_lp W=1.18e-6 L=60e-9 MR=1
MPM2 net23 A2 VDD VNW pm1p2_svt_lp W=1.18e-6 L=60e-9 MR=1
MPM1 net24 A1 net23 VNW pm1p2_svt_lp W=1.18e-6 L=60e-9 MR=1
MPM0 Y A0 net24 VNW pm1p2_svt_lp W=1.18e-6 L=60e-9 MR=1
.ENDS
.SUBCKT GOR2X1_9TSVT A B VDD VSS Y VNW VPW
MM1 VDD yn VDD VNW pm1p2_svt_lp W=590e-9 L=60e-9 MR=1
MPM2 Y yn VDD VNW pm1p2_svt_lp W=590e-9 L=60e-9 MR=1
MPM1 net18 B VDD VNW pm1p2_svt_lp W=590e-9 L=60e-9 MR=1
MPM0 yn A net18 VNW pm1p2_svt_lp W=590e-9 L=60e-9 MR=1
MM0 VSS yn VSS VPW nm1p2_svt_lp W=470e-9 L=60e-9 MR=1
MNM2 Y yn VSS VPW nm1p2_svt_lp W=470e-9 L=60e-9 MR=1
MNM1 yn B VSS VPW nm1p2_svt_lp W=470e-9 L=60e-9 MR=1
MNM0 yn A VSS VPW nm1p2_svt_lp W=470e-9 L=60e-9 MR=1
.ENDS
.SUBCKT GOR2X2_9TSVT A B VDD VSS Y VNW VPW
MPM2 Y net13 VDD VNW pm1p2_svt_lp W=1.18e-6 L=60e-9 MR=1
MPM1 net18 B VDD VNW pm1p2_svt_lp W=590e-9 L=60e-9 MR=1
MPM0 net13 A net18 VNW pm1p2_svt_lp W=590e-9 L=60e-9 MR=1
MNM2 Y net13 VSS VPW nm1p2_svt_lp W=940e-9 L=60e-9 MR=1
MNM1 net13 B VSS VPW nm1p2_svt_lp W=470e-9 L=60e-9 MR=1
MNM0 net13 A VSS VPW nm1p2_svt_lp W=470e-9 L=60e-9 MR=1
.ENDS
.SUBCKT GOR2X4_9TSVT A B VDD VSS Y VNW VPW
MPM2 Y net13 VDD VNW pm1p2_svt_lp W=2.36e-6 L=60e-9 MR=1
MPM1 net18 B VDD VNW pm1p2_svt_lp W=1.18e-6 L=60e-9 MR=1
MPM0 net13 A net18 VNW pm1p2_svt_lp W=1.18e-6 L=60e-9 MR=1
MNM2 Y net13 VSS VPW nm1p2_svt_lp W=1.88e-6 L=60e-9 MR=1
MNM1 net13 B VSS VPW nm1p2_svt_lp W=940e-9 L=60e-9 MR=1
MNM0 net13 A VSS VPW nm1p2_svt_lp W=940e-9 L=60e-9 MR=1
.ENDS
.SUBCKT GSDFFQX1_9TSVT CK D Q SE SI VDD VSS VNW VPW
MNM11 Q net40 VSS VPW nm1p2_svt_lp W=470e-9 L=60e-9 MR=1
MNM9 net46 net40 VSS VPW nm1p2_svt_lp W=470e-9 L=60e-9 MR=1
MNM10 net34 ckn net46 VPW nm1p2_svt_lp W=470e-9 L=60e-9 MR=1
MNM8 net40 net34 VSS VPW nm1p2_svt_lp W=470e-9 L=60e-9 MR=1
MNM7 net34 ckb net31 VPW nm1p2_svt_lp W=470e-9 L=60e-9 MR=1
MNM5 net48 net31 VSS VPW nm1p2_svt_lp W=470e-9 L=60e-9 MR=1
MNM6 net22 ckb net48 VPW nm1p2_svt_lp W=470e-9 L=60e-9 MR=1
MNM4 net31 net22 VSS VPW nm1p2_svt_lp W=470e-9 L=60e-9 MR=1
MNM_SE0 sen SE VSS VPW nm1p2_svt_lp W=470e-9 L=60e-9 MR=1
MNMR2 net50 SI VSS VPW nm1p2_svt_lp W=470e-9 L=60e-9 MR=1
MNML2 net51 D VSS VPW nm1p2_svt_lp W=470e-9 L=60e-9 MR=1
MNM_SE2 net18 SE net50 VPW nm1p2_svt_lp W=470e-9 L=60e-9 MR=1
MNM_SE1 net18 sen net51 VPW nm1p2_svt_lp W=470e-9 L=60e-9 MR=1
MNM3 net22 ckn net18 VPW nm1p2_svt_lp W=470e-9 L=60e-9 MR=1
MNM1 ckb ckn VSS VPW nm1p2_svt_lp W=470e-9 L=60e-9 MR=1
MNM0 ckn CK VSS VPW nm1p2_svt_lp W=470e-9 L=60e-9 MR=1
MPM11 Q net40 VDD VNW pm1p2_svt_lp W=590e-9 L=60e-9 MR=1
MPM10 net34 ckb net47 VNW pm1p2_svt_lp W=590e-9 L=60e-9 MR=1
MPM9 net47 net40 VDD VNW pm1p2_svt_lp W=590e-9 L=60e-9 MR=1
MPM8 net40 net34 VDD VNW pm1p2_svt_lp W=590e-9 L=60e-9 MR=1
MPM7 net34 ckn net31 VNW pm1p2_svt_lp W=590e-9 L=60e-9 MR=1
MPM6 net22 ckn net49 VNW pm1p2_svt_lp W=590e-9 L=60e-9 MR=1
MPM5 net49 net31 VDD VNW pm1p2_svt_lp W=590e-9 L=60e-9 MR=1
MPM4 net31 net22 VDD VNW pm1p2_svt_lp W=590e-9 L=60e-9 MR=1
MPM_SE0 sen SE VDD VNW pm1p2_svt_lp W=590e-9 L=60e-9 MR=1
MPM3 net22 ckb net18 VNW pm1p2_svt_lp W=590e-9 L=60e-9 MR=1
MPMR2 net52 SI VDD VNW pm1p2_svt_lp W=590e-9 L=60e-9 MR=1
MPML2 net53 D VDD VNW pm1p2_svt_lp W=590e-9 L=60e-9 MR=1
MPM_SE2 net18 sen net52 VNW pm1p2_svt_lp W=590e-9 L=60e-9 MR=1
MPM_SE1 net18 SE net53 VNW pm1p2_svt_lp W=590e-9 L=60e-9 MR=1
MPM1 ckb ckn VDD VNW pm1p2_svt_lp W=590e-9 L=60e-9 MR=1
MPM0 ckn CK VDD VNW pm1p2_svt_lp W=590e-9 L=60e-9 MR=1
.ENDS
.SUBCKT GSDFFRNQX1_9TSVT CK D Q RN SE SI VDD VSS VNW VPW
MNM11 Q net39 VSS VPW nm1p2_svt_lp W=470e-9 L=60e-9 MR=1
MNM9 net51 net39 VSS VPW nm1p2_svt_lp W=470e-9 L=60e-9 MR=1
MNM10 net36 ckn net51 VPW nm1p2_svt_lp W=470e-9 L=60e-9 MR=1
MNM_RN2 net53 RN VSS VPW nm1p2_svt_lp W=470e-9 L=60e-9 MR=1
MNM8 net39 net36 net53 VPW nm1p2_svt_lp W=470e-9 L=60e-9 MR=1
MNM7 net36 ckb net33 VPW nm1p2_svt_lp W=470e-9 L=60e-9 MR=1
MNM_RN net54 RN VSS VPW nm1p2_svt_lp W=470e-9 L=60e-9 MR=1
MNM5 net55 net33 net54 VPW nm1p2_svt_lp W=470e-9 L=60e-9 MR=1
MNM6 net24 ckb net55 VPW nm1p2_svt_lp W=470e-9 L=60e-9 MR=1
MNM4 net33 net24 VSS VPW nm1p2_svt_lp W=470e-9 L=60e-9 MR=1
MNM_SE0 sen SE VSS VPW nm1p2_svt_lp W=470e-9 L=60e-9 MR=1
MNMR2 net56 SI VSS VPW nm1p2_svt_lp W=470e-9 L=60e-9 MR=1
MNML2 net57 D VSS VPW nm1p2_svt_lp W=470e-9 L=60e-9 MR=1
MNM_SE2 net20 SE net56 VPW nm1p2_svt_lp W=470e-9 L=60e-9 MR=1
MNM_SE1 net20 sen net57 VPW nm1p2_svt_lp W=470e-9 L=60e-9 MR=1
MNM3 net24 ckn net20 VPW nm1p2_svt_lp W=470e-9 L=60e-9 MR=1
MNM1 ckb ckn VSS VPW nm1p2_svt_lp W=470e-9 L=60e-9 MR=1
MNM0 ckn CK VSS VPW nm1p2_svt_lp W=470e-9 L=60e-9 MR=1
MPM11 Q net39 VDD VNW pm1p2_svt_lp W=590e-9 L=60e-9 MR=1
MPM10 net36 ckb net52 VNW pm1p2_svt_lp W=590e-9 L=60e-9 MR=1
MPM9 net52 net39 VDD VNW pm1p2_svt_lp W=590e-9 L=60e-9 MR=1
MPM_RN2 net39 RN VDD VNW pm1p2_svt_lp W=590e-9 L=60e-9 MR=1
MPM8 net39 net36 VDD VNW pm1p2_svt_lp W=590e-9 L=60e-9 MR=1
MPM7 net36 ckn net33 VNW pm1p2_svt_lp W=590e-9 L=60e-9 MR=1
MPM6 net24 ckn net46 VNW pm1p2_svt_lp W=590e-9 L=60e-9 MR=1
MPM_RN net46 RN VDD VNW pm1p2_svt_lp W=590e-9 L=60e-9 MR=1
MPM5 net46 net33 VDD VNW pm1p2_svt_lp W=590e-9 L=60e-9 MR=1
MPM4 net33 net24 VDD VNW pm1p2_svt_lp W=590e-9 L=60e-9 MR=1
MPM_SE0 sen SE VDD VNW pm1p2_svt_lp W=590e-9 L=60e-9 MR=1
MPM3 net24 ckb net20 VNW pm1p2_svt_lp W=590e-9 L=60e-9 MR=1
MPMR2 net58 SI VDD VNW pm1p2_svt_lp W=590e-9 L=60e-9 MR=1
MPML2 net59 D VDD VNW pm1p2_svt_lp W=590e-9 L=60e-9 MR=1
MPM_SE2 net20 sen net58 VNW pm1p2_svt_lp W=590e-9 L=60e-9 MR=1
MPM_SE1 net20 SE net59 VNW pm1p2_svt_lp W=590e-9 L=60e-9 MR=1
MPM1 ckb ckn VDD VNW pm1p2_svt_lp W=590e-9 L=60e-9 MR=1
MPM0 ckn CK VDD VNW pm1p2_svt_lp W=590e-9 L=60e-9 MR=1
.ENDS
.SUBCKT GSDFFSNQX1_9TSVT CK D Q SE SI SN VDD VSS VNW VPW
MNM11 Q net41 VSS VPW nm1p2_svt_lp W=470e-9 L=60e-9 MR=1
MNM9 net51 net41 VSS VPW nm1p2_svt_lp W=470e-9 L=60e-9 MR=1
MNM_SN2 net52 SN net51 VPW nm1p2_svt_lp W=470e-9 L=60e-9 MR=1
MNM10 net35 ckn net52 VPW nm1p2_svt_lp W=470e-9 L=60e-9 MR=1
MNM8 net41 net35 VSS VPW nm1p2_svt_lp W=470e-9 L=60e-9 MR=1
MNM7 net35 ckb net30 VPW nm1p2_svt_lp W=470e-9 L=60e-9 MR=1
MNM5 net53 net30 VSS VPW nm1p2_svt_lp W=470e-9 L=60e-9 MR=1
MNM6 net24 ckb net53 VPW nm1p2_svt_lp W=470e-9 L=60e-9 MR=1
MNM4 net55 net24 VSS VPW nm1p2_svt_lp W=470e-9 L=60e-9 MR=1
MNM_SN net30 SN net55 VPW nm1p2_svt_lp W=470e-9 L=60e-9 MR=1
MNM_SE0 sen SE VSS VPW nm1p2_svt_lp W=470e-9 L=60e-9 MR=1
MNMR2 net56 SI VSS VPW nm1p2_svt_lp W=470e-9 L=60e-9 MR=1
MNML2 net57 D VSS VPW nm1p2_svt_lp W=470e-9 L=60e-9 MR=1
MNM_SE2 net20 SE net56 VPW nm1p2_svt_lp W=470e-9 L=60e-9 MR=1
MNM_SE1 net20 sen net57 VPW nm1p2_svt_lp W=470e-9 L=60e-9 MR=1
MNM3 net24 ckn net20 VPW nm1p2_svt_lp W=470e-9 L=60e-9 MR=1
MNM1 ckb ckn VSS VPW nm1p2_svt_lp W=470e-9 L=60e-9 MR=1
MNM0 ckn CK VSS VPW nm1p2_svt_lp W=470e-9 L=60e-9 MR=1
MPM11 Q net41 VDD VNW pm1p2_svt_lp W=590e-9 L=60e-9 MR=1
MPM10 net35 ckb net49 VNW pm1p2_svt_lp W=590e-9 L=60e-9 MR=1
MPM_SN2 net49 SN VDD VNW pm1p2_svt_lp W=590e-9 L=60e-9 MR=1
MPM9 net49 net41 VDD VNW pm1p2_svt_lp W=590e-9 L=60e-9 MR=1
MPM8 net41 net35 VDD VNW pm1p2_svt_lp W=590e-9 L=60e-9 MR=1
MPM7 net35 ckn net30 VNW pm1p2_svt_lp W=590e-9 L=60e-9 MR=1
MPM6 net24 ckn net54 VNW pm1p2_svt_lp W=590e-9 L=60e-9 MR=1
MPM5 net54 net30 VDD VNW pm1p2_svt_lp W=590e-9 L=60e-9 MR=1
MPM_SN net30 SN VDD VNW pm1p2_svt_lp W=590e-9 L=60e-9 MR=1
MPM4 net30 net24 VDD VNW pm1p2_svt_lp W=590e-9 L=60e-9 MR=1
MPM_SE0 sen SE VDD VNW pm1p2_svt_lp W=590e-9 L=60e-9 MR=1
MPM3 net24 ckb net20 VNW pm1p2_svt_lp W=590e-9 L=60e-9 MR=1
MPMR2 net58 SI VDD VNW pm1p2_svt_lp W=590e-9 L=60e-9 MR=1
MPML2 net59 D VDD VNW pm1p2_svt_lp W=590e-9 L=60e-9 MR=1
MPM_SE2 net20 sen net58 VNW pm1p2_svt_lp W=590e-9 L=60e-9 MR=1
MPM_SE1 net20 SE net59 VNW pm1p2_svt_lp W=590e-9 L=60e-9 MR=1
MPM1 ckb ckn VDD VNW pm1p2_svt_lp W=590e-9 L=60e-9 MR=1
MPM0 ckn CK VDD VNW pm1p2_svt_lp W=590e-9 L=60e-9 MR=1
.ENDS
.SUBCKT GTIEHIX1_9TSVT VDD VSS Y VNW VPW
MNM0 net5 net5 VSS VPW nm1p2_svt_lp W=940n L=60n MR=1
MPM0 Y net5 VDD VNW pm1p2_svt_lp W=1.18u L=60n MR=1
.ENDS
.SUBCKT GTIELOX1_9TSVT VDD VSS Y VNW VPW
MNM0 Y net5 VSS VPW nm1p2_svt_lp W=940n L=60n MR=1
MPM0 net5 net5 VDD VNW pm1p2_svt_lp W=1.18u L=60n MR=1
.ENDS
.SUBCKT GXNOR2X1_9TSVT A B VDD VSS Y VNW VPW
MNM5 Y net16 VSS VPW nm1p2_svt_lp W=470e-9 L=60e-9 MR=1
MNM4 net16 AN BB VPW nm1p2_svt_lp W=470e-9 L=60e-9 MR=1
MNM3 net16 A BN VPW nm1p2_svt_lp W=470e-9 L=60e-9 MR=1
MNM2 BB BN VSS VPW nm1p2_svt_lp W=470e-9 L=60e-9 MR=1
MNM1 BN B VSS VPW nm1p2_svt_lp W=470e-9 L=60e-9 MR=1
MNM0 AN A VSS VPW nm1p2_svt_lp W=470e-9 L=60e-9 MR=1
MPM5 Y net16 VDD VNW pm1p2_svt_lp W=590e-9 L=60e-9 MR=1
MPM4 net16 A BB VNW pm1p2_svt_lp W=590e-9 L=60e-9 MR=1
MPM3 net16 AN BN VNW pm1p2_svt_lp W=590e-9 L=60e-9 MR=1
MPM2 BB BN VDD VNW pm1p2_svt_lp W=590e-9 L=60e-9 MR=1
MPM1 BN B VDD VNW pm1p2_svt_lp W=590e-9 L=60e-9 MR=1
MPM0 AN A VDD VNW pm1p2_svt_lp W=590e-9 L=60e-9 MR=1
.ENDS
.SUBCKT GXNOR2X2_9TSVT A B VDD VSS Y VNW VPW
MNM5 Y net16 VSS VPW nm1p2_svt_lp W=940e-9 L=60e-9 MR=1
MNM4 net16 AN BB VPW nm1p2_svt_lp W=470e-9 L=60e-9 MR=1
MNM3 net16 A BN VPW nm1p2_svt_lp W=470e-9 L=60e-9 MR=1
MNM2 BB BN VSS VPW nm1p2_svt_lp W=470e-9 L=60e-9 MR=1
MNM1 BN B VSS VPW nm1p2_svt_lp W=940n L=60n MR=1
MNM0 AN A VSS VPW nm1p2_svt_lp W=470e-9 L=60e-9 MR=1
MPM5 Y net16 VDD VNW pm1p2_svt_lp W=1.18e-6 L=60e-9 MR=1
MPM4 net16 A BB VNW pm1p2_svt_lp W=590e-9 L=60e-9 MR=1
MPM3 net16 AN BN VNW pm1p2_svt_lp W=590e-9 L=60e-9 MR=1
MPM2 BB BN VDD VNW pm1p2_svt_lp W=590e-9 L=60e-9 MR=1
MPM1 BN B VDD VNW pm1p2_svt_lp W=1.18u L=60n MR=1
MPM0 AN A VDD VNW pm1p2_svt_lp W=590e-9 L=60e-9 MR=1
.ENDS
.SUBCKT GXOR2X1_9TSVT A B VDD VSS Y VNW VPW
MNM5 Y net16 VSS VPW nm1p2_svt_lp W=470e-9 L=60e-9 MR=1
MNM4 net16 AN BN VPW nm1p2_svt_lp W=470e-9 L=60e-9 MR=1
MNM3 net16 A BB VPW nm1p2_svt_lp W=470e-9 L=60e-9 MR=1
MNM2 BB BN VSS VPW nm1p2_svt_lp W=470e-9 L=60e-9 MR=1
MNM1 BN B VSS VPW nm1p2_svt_lp W=470e-9 L=60e-9 MR=1
MNM0 AN A VSS VPW nm1p2_svt_lp W=470e-9 L=60e-9 MR=1
MPM5 Y net16 VDD VNW pm1p2_svt_lp W=590e-9 L=60e-9 MR=1
MPM4 net16 A BN VNW pm1p2_svt_lp W=590e-9 L=60e-9 MR=1
MPM3 net16 AN BB VNW pm1p2_svt_lp W=590e-9 L=60e-9 MR=1
MPM2 BB BN VDD VNW pm1p2_svt_lp W=590e-9 L=60e-9 MR=1
MPM1 BN B VDD VNW pm1p2_svt_lp W=590e-9 L=60e-9 MR=1
MPM0 AN A VDD VNW pm1p2_svt_lp W=590e-9 L=60e-9 MR=1
.ENDS
.SUBCKT GXOR2X2_9TSVT A B VDD VSS Y VNW VPW
MNM5 Y net16 VSS VPW nm1p2_svt_lp W=940e-9 L=60e-9 MR=1
MNM4 net16 AN BN VPW nm1p2_svt_lp W=470e-9 L=60e-9 MR=1
MNM3 net16 A BB VPW nm1p2_svt_lp W=470e-9 L=60e-9 MR=1
MNM2 BB BN VSS VPW nm1p2_svt_lp W=470e-9 L=60e-9 MR=1
MNM1 BN B VSS VPW nm1p2_svt_lp W=940n L=60n MR=1
MNM0 AN A VSS VPW nm1p2_svt_lp W=470e-9 L=60e-9 MR=1
MPM5 Y net16 VDD VNW pm1p2_svt_lp W=1.18e-6 L=60e-9 MR=1
MPM4 net16 A BN VNW pm1p2_svt_lp W=590e-9 L=60e-9 MR=1
MPM3 net16 AN BB VNW pm1p2_svt_lp W=590e-9 L=60e-9 MR=1
MPM2 BB BN VDD VNW pm1p2_svt_lp W=590e-9 L=60e-9 MR=1
MPM1 BN B VDD VNW pm1p2_svt_lp W=1.18u L=60n MR=1
MPM0 AN A VDD VNW pm1p2_svt_lp W=590e-9 L=60e-9 MR=1
.ENDS
