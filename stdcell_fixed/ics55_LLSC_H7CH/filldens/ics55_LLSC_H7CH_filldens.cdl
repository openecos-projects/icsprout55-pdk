* density filler cells (hacking/stdcell_fix/density_fill.py): no devices
.SUBCKT FILLDENS4H7H VDD VSS
*.PININFO VDD:B VSS:B
.ENDS

.SUBCKT FILLDENS8H7H VDD VSS
*.PININFO VDD:B VSS:B
.ENDS

.SUBCKT FILLDENS16H7H VDD VSS
*.PININFO VDD:B VSS:B
.ENDS

.SUBCKT FILLDENS32H7H VDD VSS
*.PININFO VDD:B VSS:B
.ENDS

.SUBCKT FILLDENS64H7H VDD VSS
*.PININFO VDD:B VSS:B
.ENDS
